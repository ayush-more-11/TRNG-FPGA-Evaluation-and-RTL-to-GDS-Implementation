* NGSPICE file created from trng_top.ext - technology: sky130A

* Black-box entry subcircuit for sky130_fd_sc_hd__tapvpwrvgnd_1 abstract view
.subckt sky130_fd_sc_hd__tapvpwrvgnd_1 VGND VPWR
.ends

* Black-box entry subcircuit for sky130_fd_sc_hd__fill_1 abstract view
.subckt sky130_fd_sc_hd__fill_1 VGND VNB VPB VPWR
.ends

* Black-box entry subcircuit for sky130_fd_sc_hd__decap_8 abstract view
.subckt sky130_fd_sc_hd__decap_8 VGND VNB VPB VPWR
.ends

* Black-box entry subcircuit for sky130_ef_sc_hd__decap_12 abstract view
.subckt sky130_ef_sc_hd__decap_12 VPWR VGND VPB VNB
.ends

* Black-box entry subcircuit for sky130_fd_sc_hd__dfxtp_1 abstract view
.subckt sky130_fd_sc_hd__dfxtp_1 CLK D VGND VNB VPB VPWR Q
.ends

* Black-box entry subcircuit for sky130_fd_sc_hd__decap_3 abstract view
.subckt sky130_fd_sc_hd__decap_3 VGND VNB VPB VPWR
.ends

* Black-box entry subcircuit for sky130_fd_sc_hd__clkbuf_4 abstract view
.subckt sky130_fd_sc_hd__clkbuf_4 A VGND VNB VPB VPWR X
.ends

* Black-box entry subcircuit for sky130_fd_sc_hd__and3_1 abstract view
.subckt sky130_fd_sc_hd__and3_1 A B C VGND VNB VPB VPWR X
.ends

* Black-box entry subcircuit for sky130_fd_sc_hd__nand2_1 abstract view
.subckt sky130_fd_sc_hd__nand2_1 A B VGND VNB VPB VPWR Y
.ends

* Black-box entry subcircuit for sky130_fd_sc_hd__clkbuf_8 abstract view
.subckt sky130_fd_sc_hd__clkbuf_8 A VGND VNB VPB VPWR X
.ends

* Black-box entry subcircuit for sky130_fd_sc_hd__or2_1 abstract view
.subckt sky130_fd_sc_hd__or2_1 A B VGND VNB VPB VPWR X
.ends

* Black-box entry subcircuit for sky130_fd_sc_hd__and2_1 abstract view
.subckt sky130_fd_sc_hd__and2_1 A B VGND VNB VPB VPWR X
.ends

* Black-box entry subcircuit for sky130_fd_sc_hd__decap_4 abstract view
.subckt sky130_fd_sc_hd__decap_4 VGND VNB VPB VPWR
.ends

* Black-box entry subcircuit for sky130_fd_sc_hd__decap_6 abstract view
.subckt sky130_fd_sc_hd__decap_6 VGND VNB VPB VPWR
.ends

* Black-box entry subcircuit for sky130_fd_sc_hd__nor2_1 abstract view
.subckt sky130_fd_sc_hd__nor2_1 A B VGND VNB VPB VPWR Y
.ends

* Black-box entry subcircuit for sky130_fd_sc_hd__dfxtp_2 abstract view
.subckt sky130_fd_sc_hd__dfxtp_2 CLK D VGND VNB VPB VPWR Q
.ends

* Black-box entry subcircuit for sky130_fd_sc_hd__o211a_1 abstract view
.subckt sky130_fd_sc_hd__o211a_1 A1 A2 B1 C1 VGND VNB VPB VPWR X
.ends

* Black-box entry subcircuit for sky130_fd_sc_hd__a21oi_1 abstract view
.subckt sky130_fd_sc_hd__a21oi_1 A1 A2 B1 VGND VNB VPB VPWR Y
.ends

* Black-box entry subcircuit for sky130_fd_sc_hd__and3b_1 abstract view
.subckt sky130_fd_sc_hd__and3b_1 A_N B C VGND VNB VPB VPWR X
.ends

* Black-box entry subcircuit for sky130_fd_sc_hd__dlygate4sd3_1 abstract view
.subckt sky130_fd_sc_hd__dlygate4sd3_1 A VGND VNB VPB VPWR X
.ends

* Black-box entry subcircuit for sky130_fd_sc_hd__fill_2 abstract view
.subckt sky130_fd_sc_hd__fill_2 VGND VNB VPB VPWR
.ends

* Black-box entry subcircuit for sky130_fd_sc_hd__buf_2 abstract view
.subckt sky130_fd_sc_hd__buf_2 A VGND VNB VPB VPWR X
.ends

* Black-box entry subcircuit for sky130_fd_sc_hd__inv_1 abstract view
.subckt sky130_fd_sc_hd__inv_1 A VGND VNB VPB VPWR Y
.ends

* Black-box entry subcircuit for sky130_fd_sc_hd__o221a_1 abstract view
.subckt sky130_fd_sc_hd__o221a_1 A1 A2 B1 B2 C1 VGND VNB VPB VPWR X
.ends

* Black-box entry subcircuit for sky130_fd_sc_hd__inv_2 abstract view
.subckt sky130_fd_sc_hd__inv_2 A VGND VNB VPB VPWR Y
.ends

* Black-box entry subcircuit for sky130_fd_sc_hd__clkbuf_1 abstract view
.subckt sky130_fd_sc_hd__clkbuf_1 A VGND VNB VPB VPWR X
.ends

* Black-box entry subcircuit for sky130_fd_sc_hd__a22o_1 abstract view
.subckt sky130_fd_sc_hd__a22o_1 A1 A2 B1 B2 VGND VNB VPB VPWR X
.ends

* Black-box entry subcircuit for sky130_fd_sc_hd__o21ai_1 abstract view
.subckt sky130_fd_sc_hd__o21ai_1 A1 A2 B1 VGND VNB VPB VPWR Y
.ends

* Black-box entry subcircuit for sky130_fd_sc_hd__o311a_1 abstract view
.subckt sky130_fd_sc_hd__o311a_1 A1 A2 A3 B1 C1 VGND VNB VPB VPWR X
.ends

* Black-box entry subcircuit for sky130_fd_sc_hd__a41o_1 abstract view
.subckt sky130_fd_sc_hd__a41o_1 A1 A2 A3 A4 B1 VGND VNB VPB VPWR X
.ends

* Black-box entry subcircuit for sky130_fd_sc_hd__a21boi_1 abstract view
.subckt sky130_fd_sc_hd__a21boi_1 A1 A2 B1_N VGND VNB VPB VPWR Y
.ends

* Black-box entry subcircuit for sky130_fd_sc_hd__or3_1 abstract view
.subckt sky130_fd_sc_hd__or3_1 A B C VGND VNB VPB VPWR X
.ends

* Black-box entry subcircuit for sky130_fd_sc_hd__or4_2 abstract view
.subckt sky130_fd_sc_hd__or4_2 A B C D VGND VNB VPB VPWR X
.ends

* Black-box entry subcircuit for sky130_fd_sc_hd__and2b_1 abstract view
.subckt sky130_fd_sc_hd__and2b_1 A_N B VGND VNB VPB VPWR X
.ends

* Black-box entry subcircuit for sky130_fd_sc_hd__a211o_1 abstract view
.subckt sky130_fd_sc_hd__a211o_1 A1 A2 B1 C1 VGND VNB VPB VPWR X
.ends

* Black-box entry subcircuit for sky130_fd_sc_hd__a31o_1 abstract view
.subckt sky130_fd_sc_hd__a31o_1 A1 A2 A3 B1 VGND VNB VPB VPWR X
.ends

* Black-box entry subcircuit for sky130_fd_sc_hd__and4_1 abstract view
.subckt sky130_fd_sc_hd__and4_1 A B C D VGND VNB VPB VPWR X
.ends

* Black-box entry subcircuit for sky130_fd_sc_hd__mux2_1 abstract view
.subckt sky130_fd_sc_hd__mux2_1 A0 A1 S VGND VNB VPB VPWR X
.ends

* Black-box entry subcircuit for sky130_fd_sc_hd__o21a_1 abstract view
.subckt sky130_fd_sc_hd__o21a_1 A1 A2 B1 VGND VNB VPB VPWR X
.ends

* Black-box entry subcircuit for sky130_fd_sc_hd__or4_1 abstract view
.subckt sky130_fd_sc_hd__or4_1 A B C D VGND VNB VPB VPWR X
.ends

* Black-box entry subcircuit for sky130_fd_sc_hd__o2111a_1 abstract view
.subckt sky130_fd_sc_hd__o2111a_1 A1 A2 B1 C1 D1 VGND VNB VPB VPWR X
.ends

* Black-box entry subcircuit for sky130_fd_sc_hd__nor2_2 abstract view
.subckt sky130_fd_sc_hd__nor2_2 A B VGND VNB VPB VPWR Y
.ends

* Black-box entry subcircuit for sky130_fd_sc_hd__a21o_1 abstract view
.subckt sky130_fd_sc_hd__a21o_1 A1 A2 B1 VGND VNB VPB VPWR X
.ends

* Black-box entry subcircuit for sky130_fd_sc_hd__and4_2 abstract view
.subckt sky130_fd_sc_hd__and4_2 A B C D VGND VNB VPB VPWR X
.ends

* Black-box entry subcircuit for sky130_fd_sc_hd__or2_2 abstract view
.subckt sky130_fd_sc_hd__or2_2 A B VGND VNB VPB VPWR X
.ends

* Black-box entry subcircuit for sky130_fd_sc_hd__or4b_1 abstract view
.subckt sky130_fd_sc_hd__or4b_1 A B C D_N VGND VNB VPB VPWR X
.ends

* Black-box entry subcircuit for sky130_fd_sc_hd__xor2_1 abstract view
.subckt sky130_fd_sc_hd__xor2_1 A B VGND VNB VPB VPWR X
.ends

* Black-box entry subcircuit for sky130_fd_sc_hd__a32o_1 abstract view
.subckt sky130_fd_sc_hd__a32o_1 A1 A2 A3 B1 B2 VGND VNB VPB VPWR X
.ends

* Black-box entry subcircuit for sky130_fd_sc_hd__a221oi_1 abstract view
.subckt sky130_fd_sc_hd__a221oi_1 A1 A2 B1 B2 C1 VGND VNB VPB VPWR Y
.ends

* Black-box entry subcircuit for sky130_fd_sc_hd__o41a_1 abstract view
.subckt sky130_fd_sc_hd__o41a_1 A1 A2 A3 A4 B1 VGND VNB VPB VPWR X
.ends

* Black-box entry subcircuit for sky130_fd_sc_hd__nand4_1 abstract view
.subckt sky130_fd_sc_hd__nand4_1 A B C D VGND VNB VPB VPWR Y
.ends

* Black-box entry subcircuit for sky130_fd_sc_hd__o31a_1 abstract view
.subckt sky130_fd_sc_hd__o31a_1 A1 A2 A3 B1 VGND VNB VPB VPWR X
.ends

* Black-box entry subcircuit for sky130_fd_sc_hd__clkbuf_16 abstract view
.subckt sky130_fd_sc_hd__clkbuf_16 A VGND VNB VPB VPWR X
.ends

* Black-box entry subcircuit for sky130_fd_sc_hd__xnor2_1 abstract view
.subckt sky130_fd_sc_hd__xnor2_1 A B VGND VNB VPB VPWR Y
.ends

* Black-box entry subcircuit for sky130_fd_sc_hd__or3b_2 abstract view
.subckt sky130_fd_sc_hd__or3b_2 A B C_N VGND VNB VPB VPWR X
.ends

* Black-box entry subcircuit for sky130_fd_sc_hd__buf_1 abstract view
.subckt sky130_fd_sc_hd__buf_1 A VGND VNB VPB VPWR X
.ends

* Black-box entry subcircuit for sky130_fd_sc_hd__a2bb2o_1 abstract view
.subckt sky130_fd_sc_hd__a2bb2o_1 A1_N A2_N B1 B2 VGND VNB VPB VPWR X
.ends

* Black-box entry subcircuit for sky130_fd_sc_hd__or4_4 abstract view
.subckt sky130_fd_sc_hd__or4_4 A B C D VGND VNB VPB VPWR X
.ends

* Black-box entry subcircuit for sky130_fd_sc_hd__a211oi_1 abstract view
.subckt sky130_fd_sc_hd__a211oi_1 A1 A2 B1 C1 VGND VNB VPB VPWR Y
.ends

* Black-box entry subcircuit for sky130_fd_sc_hd__conb_1 abstract view
.subckt sky130_fd_sc_hd__conb_1 VGND VNB VPB VPWR HI LO
.ends

* Black-box entry subcircuit for sky130_fd_sc_hd__nand2_2 abstract view
.subckt sky130_fd_sc_hd__nand2_2 A B VGND VNB VPB VPWR Y
.ends

* Black-box entry subcircuit for sky130_fd_sc_hd__clkbuf_2 abstract view
.subckt sky130_fd_sc_hd__clkbuf_2 A VGND VNB VPB VPWR X
.ends

* Black-box entry subcircuit for sky130_fd_sc_hd__or4bb_1 abstract view
.subckt sky130_fd_sc_hd__or4bb_1 A B C_N D_N VGND VNB VPB VPWR X
.ends

* Black-box entry subcircuit for sky130_fd_sc_hd__o32a_1 abstract view
.subckt sky130_fd_sc_hd__o32a_1 A1 A2 A3 B1 B2 VGND VNB VPB VPWR X
.ends

* Black-box entry subcircuit for sky130_fd_sc_hd__o211ai_1 abstract view
.subckt sky130_fd_sc_hd__o211ai_1 A1 A2 B1 C1 VGND VNB VPB VPWR Y
.ends

* Black-box entry subcircuit for sky130_fd_sc_hd__or3b_1 abstract view
.subckt sky130_fd_sc_hd__or3b_1 A B C_N VGND VNB VPB VPWR X
.ends

* Black-box entry subcircuit for sky130_fd_sc_hd__a21bo_1 abstract view
.subckt sky130_fd_sc_hd__a21bo_1 A1 A2 B1_N VGND VNB VPB VPWR X
.ends

* Black-box entry subcircuit for sky130_fd_sc_hd__nor4_1 abstract view
.subckt sky130_fd_sc_hd__nor4_1 A B C D VGND VNB VPB VPWR Y
.ends

* Black-box entry subcircuit for sky130_fd_sc_hd__o22a_1 abstract view
.subckt sky130_fd_sc_hd__o22a_1 A1 A2 B1 B2 VGND VNB VPB VPWR X
.ends

* Black-box entry subcircuit for sky130_fd_sc_hd__and4bb_1 abstract view
.subckt sky130_fd_sc_hd__and4bb_1 A_N B_N C D VGND VNB VPB VPWR X
.ends

* Black-box entry subcircuit for sky130_fd_sc_hd__nand3_1 abstract view
.subckt sky130_fd_sc_hd__nand3_1 A B C VGND VNB VPB VPWR Y
.ends

* Black-box entry subcircuit for sky130_fd_sc_hd__buf_4 abstract view
.subckt sky130_fd_sc_hd__buf_4 A VGND VNB VPB VPWR X
.ends

* Black-box entry subcircuit for sky130_fd_sc_hd__o2bb2a_1 abstract view
.subckt sky130_fd_sc_hd__o2bb2a_1 A1_N A2_N B1 B2 VGND VNB VPB VPWR X
.ends

* Black-box entry subcircuit for sky130_fd_sc_hd__or2b_1 abstract view
.subckt sky130_fd_sc_hd__or2b_1 A B_N VGND VNB VPB VPWR X
.ends

* Black-box entry subcircuit for sky130_fd_sc_hd__a31o_2 abstract view
.subckt sky130_fd_sc_hd__a31o_2 A1 A2 A3 B1 VGND VNB VPB VPWR X
.ends

* Black-box entry subcircuit for sky130_fd_sc_hd__a31oi_4 abstract view
.subckt sky130_fd_sc_hd__a31oi_4 A1 A2 A3 B1 VGND VNB VPB VPWR Y
.ends

* Black-box entry subcircuit for sky130_fd_sc_hd__nor3_1 abstract view
.subckt sky130_fd_sc_hd__nor3_1 A B C VGND VNB VPB VPWR Y
.ends

* Black-box entry subcircuit for sky130_fd_sc_hd__nor2b_4 abstract view
.subckt sky130_fd_sc_hd__nor2b_4 A B_N VGND VNB VPB VPWR Y
.ends

* Black-box entry subcircuit for sky130_fd_sc_hd__o31ai_1 abstract view
.subckt sky130_fd_sc_hd__o31ai_1 A1 A2 A3 B1 VGND VNB VPB VPWR Y
.ends

* Black-box entry subcircuit for sky130_fd_sc_hd__a21oi_4 abstract view
.subckt sky130_fd_sc_hd__a21oi_4 A1 A2 B1 VGND VNB VPB VPWR Y
.ends

* Black-box entry subcircuit for sky130_fd_sc_hd__a21o_2 abstract view
.subckt sky130_fd_sc_hd__a21o_2 A1 A2 B1 VGND VNB VPB VPWR X
.ends

* Black-box entry subcircuit for sky130_fd_sc_hd__xor2_2 abstract view
.subckt sky130_fd_sc_hd__xor2_2 A B VGND VNB VPB VPWR X
.ends

* Black-box entry subcircuit for sky130_fd_sc_hd__dfrtp_4 abstract view
.subckt sky130_fd_sc_hd__dfrtp_4 CLK D RESET_B VGND VNB VPB VPWR Q
.ends

* Black-box entry subcircuit for sky130_fd_sc_hd__and3_2 abstract view
.subckt sky130_fd_sc_hd__and3_2 A B C VGND VNB VPB VPWR X
.ends

* Black-box entry subcircuit for sky130_fd_sc_hd__dfrtp_1 abstract view
.subckt sky130_fd_sc_hd__dfrtp_1 CLK D RESET_B VGND VNB VPB VPWR Q
.ends

.subckt trng_top VGND VPWR clk dbg_raw_bit dbg_raw_valid health_fail rst_n tx
XTAP_177 VGND VPWR sky130_fd_sc_hd__tapvpwrvgnd_1
XTAP_188 VGND VPWR sky130_fd_sc_hd__tapvpwrvgnd_1
XTAP_199 VGND VPWR sky130_fd_sc_hd__tapvpwrvgnd_1
XFILLER_0_27_82 VGND VGND VPWR VPWR sky130_fd_sc_hd__fill_1
XFILLER_0_4_171 VGND VGND VPWR VPWR sky130_fd_sc_hd__decap_8
XFILLER_0_23_203 VGND VGND VPWR VPWR sky130_fd_sc_hd__fill_1
XFILLER_0_48_15 VPWR VGND VPWR VGND sky130_ef_sc_hd__decap_12
X_1270_ clknet_4_6_0_clk _0052_ VGND VGND VPWR VPWR u_apt.idx\[4\] sky130_fd_sc_hd__dfxtp_1
XFILLER_0_13_73 VGND VGND VPWR VPWR sky130_fd_sc_hd__decap_3
X_0985_ u_uart.busy VGND VGND VPWR VPWR _0437_ sky130_fd_sc_hd__clkbuf_4
XFILLER_0_20_206 VGND VGND VPWR VPWR sky130_fd_sc_hd__decap_8
XFILLER_0_18_29 VPWR VGND VPWR VGND sky130_ef_sc_hd__decap_12
X_0770_ u_rct.cnt\[4\] u_rct.cnt\[3\] _0269_ VGND VGND VPWR VPWR _0270_ sky130_fd_sc_hd__and3_1
X_1322_ clknet_4_8_0_clk _0104_ VGND VGND VPWR VPWR u_uart.clk_cnt\[6\] sky130_fd_sc_hd__dfxtp_1
X_1253_ clknet_4_2_0_clk _0037_ VGND VGND VPWR VPWR warm\[15\] sky130_fd_sc_hd__dfxtp_1
X_1184_ _0583_ _0581_ VGND VGND VPWR VPWR _0584_ sky130_fd_sc_hd__nand2_1
Xclkbuf_4_12_0_clk clknet_0_clk VGND VGND VPWR VPWR clknet_4_12_0_clk sky130_fd_sc_hd__clkbuf_8
XFILLER_0_6_277 VPWR VGND VPWR VGND sky130_ef_sc_hd__decap_12
X_0968_ _0188_ _0233_ VGND VGND VPWR VPWR _0422_ sky130_fd_sc_hd__or2_1
X_0899_ _0175_ _0368_ VGND VGND VPWR VPWR _0369_ sky130_fd_sc_hd__and2_1
XFILLER_0_37_103 VGND VGND VPWR VPWR sky130_fd_sc_hd__decap_8
XFILLER_0_45_27 VGND VGND VPWR VPWR sky130_fd_sc_hd__decap_8
XFILLER_0_0_29 VPWR VGND VPWR VGND sky130_ef_sc_hd__decap_12
X_0822_ _0201_ _0308_ _0309_ VGND VGND VPWR VPWR _0310_ sky130_fd_sc_hd__and3_1
XFILLER_0_28_136 VGND VGND VPWR VPWR sky130_fd_sc_hd__decap_4
XFILLER_0_10_85 VGND VGND VPWR VPWR sky130_fd_sc_hd__decap_6
X_0753_ _0260_ _0261_ VGND VGND VPWR VPWR _0029_ sky130_fd_sc_hd__nor2_1
X_0684_ _0177_ _0176_ VGND VGND VPWR VPWR _0207_ sky130_fd_sc_hd__nand2_1
X_1305_ clknet_4_10_0_clk _0087_ VGND VGND VPWR VPWR u_uart.shreg\[1\] sky130_fd_sc_hd__dfxtp_1
X_1236_ clknet_4_1_0_clk net61 VGND VGND VPWR VPWR u_ro_bank.en sky130_fd_sc_hd__dfxtp_2
X_1167_ div\[19\] div\[18\] _0565_ VGND VGND VPWR VPWR _0571_ sky130_fd_sc_hd__and3_1
X_1098_ _0520_ VGND VGND VPWR VPWR _0521_ sky130_fd_sc_hd__clkbuf_4
XFILLER_0_27_180 VPWR VGND VPWR VGND sky130_ef_sc_hd__decap_12
XFILLER_0_48_209 VPWR VGND VPWR VGND sky130_ef_sc_hd__decap_12
X_1021_ net59 _0459_ _0463_ _0456_ VGND VGND VPWR VPWR _0095_ sky130_fd_sc_hd__o211a_1
X_0805_ _0271_ _0296_ net95 VGND VGND VPWR VPWR _0298_ sky130_fd_sc_hd__a21oi_1
XFILLER_0_21_51 VGND VGND VPWR VPWR sky130_fd_sc_hd__decap_4
XFILLER_0_21_73 VGND VGND VPWR VPWR sky130_fd_sc_hd__decap_6
X_0736_ _0247_ _0165_ _0248_ VGND VGND VPWR VPWR _0249_ sky130_fd_sc_hd__and3b_1
X_0667_ _0157_ _0183_ VGND VGND VPWR VPWR _0194_ sky130_fd_sc_hd__nand2_1
XFILLER_0_46_81 VGND VGND VPWR VPWR sky130_fd_sc_hd__decap_3
XFILLER_0_34_3 VGND VGND VPWR VPWR sky130_fd_sc_hd__fill_1
X_1219_ clknet_4_11_0_clk net35 VGND VGND VPWR VPWR u_uart.tx_data\[4\] sky130_fd_sc_hd__dfxtp_1
XFILLER_0_1_50 VGND VGND VPWR VPWR sky130_fd_sc_hd__decap_6
XFILLER_0_22_109 VGND VGND VPWR VPWR sky130_fd_sc_hd__fill_1
Xhold74 u_rct.cnt\[4\] VGND VGND VPWR VPWR net80 sky130_fd_sc_hd__dlygate4sd3_1
Xhold63 div\[28\] VGND VGND VPWR VPWR net69 sky130_fd_sc_hd__dlygate4sd3_1
XFILLER_0_30_197 VGND VGND VPWR VPWR sky130_fd_sc_hd__decap_4
XFILLER_0_30_186 VGND VGND VPWR VPWR sky130_fd_sc_hd__decap_8
Xhold41 _0001_ VGND VGND VPWR VPWR net47 sky130_fd_sc_hd__dlygate4sd3_1
Xhold52 u_apt.idx\[9\] VGND VGND VPWR VPWR net58 sky130_fd_sc_hd__dlygate4sd3_1
Xhold30 u_vn.have VGND VGND VPWR VPWR net36 sky130_fd_sc_hd__dlygate4sd3_1
Xhold85 div\[14\] VGND VGND VPWR VPWR net91 sky130_fd_sc_hd__dlygate4sd3_1
Xhold96 u_uart.bit_cnt\[2\] VGND VGND VPWR VPWR net102 sky130_fd_sc_hd__dlygate4sd3_1
XFILLER_0_38_264 VGND VGND VPWR VPWR sky130_fd_sc_hd__fill_1
XTAP_348 VGND VPWR sky130_fd_sc_hd__tapvpwrvgnd_1
XTAP_337 VGND VPWR sky130_fd_sc_hd__tapvpwrvgnd_1
XTAP_326 VGND VPWR sky130_fd_sc_hd__tapvpwrvgnd_1
XTAP_315 VGND VPWR sky130_fd_sc_hd__tapvpwrvgnd_1
XTAP_304 VGND VPWR sky130_fd_sc_hd__tapvpwrvgnd_1
XFILLER_0_8_147 VPWR VGND VPWR VGND sky130_ef_sc_hd__decap_12
X_1004_ net28 _0440_ _0451_ _0372_ VGND VGND VPWR VPWR _0090_ sky130_fd_sc_hd__o211a_1
XFILLER_0_44_289 VGND VGND VPWR VPWR sky130_fd_sc_hd__fill_2
X_0719_ u_apt.rst_n VGND VGND VPWR VPWR _0237_ sky130_fd_sc_hd__buf_2
XFILLER_0_35_245 VGND VGND VPWR VPWR sky130_fd_sc_hd__fill_1
XFILLER_0_35_223 VGND VGND VPWR VPWR sky130_fd_sc_hd__fill_1
XFILLER_0_5_117 VGND VGND VPWR VPWR sky130_fd_sc_hd__fill_1
XFILLER_0_26_289 VGND VGND VPWR VPWR sky130_fd_sc_hd__fill_2
XTAP_134 VGND VPWR sky130_fd_sc_hd__tapvpwrvgnd_1
XTAP_123 VGND VPWR sky130_fd_sc_hd__tapvpwrvgnd_1
XTAP_101 VGND VPWR sky130_fd_sc_hd__tapvpwrvgnd_1
XTAP_112 VGND VPWR sky130_fd_sc_hd__tapvpwrvgnd_1
XTAP_145 VGND VPWR sky130_fd_sc_hd__tapvpwrvgnd_1
XTAP_156 VGND VPWR sky130_fd_sc_hd__tapvpwrvgnd_1
XTAP_167 VGND VPWR sky130_fd_sc_hd__tapvpwrvgnd_1
XTAP_178 VGND VPWR sky130_fd_sc_hd__tapvpwrvgnd_1
XTAP_189 VGND VPWR sky130_fd_sc_hd__tapvpwrvgnd_1
Xu_ro_bank.g_ro\[4\].u_ro.g_stg\[7\].u_inv_u_cell u_ro_bank.g_ro\[4\].u_ro.n\[6\]
+ VGND VGND VPWR VPWR u_ro_bank.g_ro\[4\].u_ro.n\[7\] sky130_fd_sc_hd__inv_1
XFILLER_0_17_223 VGND VGND VPWR VPWR sky130_fd_sc_hd__fill_1
XFILLER_0_17_289 VGND VGND VPWR VPWR sky130_fd_sc_hd__fill_2
XFILLER_0_2_109 VPWR VGND VPWR VGND sky130_ef_sc_hd__decap_12
XFILLER_0_48_27 VGND VGND VPWR VPWR sky130_fd_sc_hd__fill_1
XFILLER_0_31_281 VGND VGND VPWR VPWR sky130_fd_sc_hd__decap_8
X_0984_ net63 _0425_ _0430_ _0436_ _0206_ VGND VGND VPWR VPWR _0085_ sky130_fd_sc_hd__o221a_1
XFILLER_0_13_52 VGND VGND VPWR VPWR sky130_fd_sc_hd__fill_1
XFILLER_0_1_175 VGND VGND VPWR VPWR sky130_fd_sc_hd__fill_1
XFILLER_0_9_231 VGND VGND VPWR VPWR sky130_fd_sc_hd__decap_3
XFILLER_0_9_242 VGND VGND VPWR VPWR sky130_fd_sc_hd__decap_4
XFILLER_0_34_29 VGND VGND VPWR VPWR sky130_fd_sc_hd__decap_6
X_1321_ clknet_4_2_0_clk net57 VGND VGND VPWR VPWR u_uart.clk_cnt\[5\] sky130_fd_sc_hd__dfxtp_1
X_1252_ clknet_4_2_0_clk _0036_ VGND VGND VPWR VPWR warm\[14\] sky130_fd_sc_hd__dfxtp_1
X_1183_ net98 VGND VGND VPWR VPWR _0583_ sky130_fd_sc_hd__inv_2
XFILLER_0_24_73 VGND VGND VPWR VPWR sky130_fd_sc_hd__fill_1
XFILLER_0_46_137 VGND VGND VPWR VPWR sky130_fd_sc_hd__decap_3
XFILLER_0_6_289 VGND VGND VPWR VPWR sky130_fd_sc_hd__fill_2
X_0967_ _0421_ VGND VGND VPWR VPWR _0083_ sky130_fd_sc_hd__clkbuf_1
X_0898_ u_apt.cnt\[3\] _0351_ _0354_ _0367_ VGND VGND VPWR VPWR _0368_ sky130_fd_sc_hd__a22o_1
XFILLER_0_10_262 VGND VGND VPWR VPWR sky130_fd_sc_hd__fill_1
XFILLER_0_37_126 VPWR VGND VPWR VGND sky130_ef_sc_hd__decap_12
XFILLER_0_29_18 VGND VGND VPWR VPWR sky130_fd_sc_hd__fill_1
XFILLER_0_29_29 VGND VGND VPWR VPWR sky130_fd_sc_hd__fill_2
XFILLER_0_45_39 VGND VGND VPWR VPWR sky130_fd_sc_hd__fill_1
X_0821_ u_apt.idx\[2\] _0305_ VGND VGND VPWR VPWR _0309_ sky130_fd_sc_hd__nand2_1
X_0752_ net15 _0257_ _0206_ VGND VGND VPWR VPWR _0261_ sky130_fd_sc_hd__o21ai_1
Xu_ro_bank.g_ro\[3\].u_ro.g_stg\[3\].u_inv_u_cell u_ro_bank.g_ro\[3\].u_ro.n\[2\]
+ VGND VGND VPWR VPWR u_ro_bank.g_ro\[3\].u_ro.n\[3\] sky130_fd_sc_hd__inv_1
X_0683_ _0176_ _0158_ _0189_ _0205_ _0206_ VGND VGND VPWR VPWR _0014_ sky130_fd_sc_hd__o311a_1
X_1166_ _0570_ VGND VGND VPWR VPWR _0133_ sky130_fd_sc_hd__clkbuf_1
X_1304_ clknet_4_10_0_clk _0086_ VGND VGND VPWR VPWR u_uart.shreg\[0\] sky130_fd_sc_hd__dfxtp_1
X_1235_ clknet_4_0_0_clk _0020_ VGND VGND VPWR VPWR net2 sky130_fd_sc_hd__dfxtp_1
XFILLER_0_19_95 VPWR VGND VPWR VGND sky130_ef_sc_hd__decap_12
X_1097_ u_apt.rst_n _0295_ VGND VGND VPWR VPWR _0520_ sky130_fd_sc_hd__and2_1
XFILLER_0_42_173 VGND VGND VPWR VPWR sky130_fd_sc_hd__decap_4
XFILLER_0_27_192 VGND VGND VPWR VPWR sky130_fd_sc_hd__decap_4
XFILLER_0_33_151 VPWR VGND VPWR VGND sky130_ef_sc_hd__decap_12
X_1020_ _0426_ _0425_ _0428_ _0462_ _0439_ VGND VGND VPWR VPWR _0463_ sky130_fd_sc_hd__a41o_1
Xclkbuf_4_11_0_clk clknet_0_clk VGND VGND VPWR VPWR clknet_4_11_0_clk sky130_fd_sc_hd__clkbuf_8
X_0804_ _0278_ _0293_ _0297_ _0172_ VGND VGND VPWR VPWR _0044_ sky130_fd_sc_hd__o211a_1
X_0735_ warm\[3\] _0244_ VGND VGND VPWR VPWR _0248_ sky130_fd_sc_hd__or2_1
X_0666_ _0193_ VGND VGND VPWR VPWR _0010_ sky130_fd_sc_hd__clkbuf_1
X_1149_ div\[14\] _0555_ _0521_ VGND VGND VPWR VPWR _0558_ sky130_fd_sc_hd__a21boi_1
X_1218_ clknet_4_11_0_clk net33 VGND VGND VPWR VPWR u_uart.tx_data\[3\] sky130_fd_sc_hd__dfxtp_1
XFILLER_0_27_3 VGND VGND VPWR VPWR sky130_fd_sc_hd__decap_4
XFILLER_0_47_210 VPWR VGND VPWR VGND sky130_ef_sc_hd__decap_12
Xhold97 u_uart.bit_cnt\[3\] VGND VGND VPWR VPWR net103 sky130_fd_sc_hd__dlygate4sd3_1
Xhold53 u_uart.bit_cnt\[1\] VGND VGND VPWR VPWR net59 sky130_fd_sc_hd__dlygate4sd3_1
Xhold64 warm\[13\] VGND VGND VPWR VPWR net70 sky130_fd_sc_hd__dlygate4sd3_1
Xhold75 warm\[14\] VGND VGND VPWR VPWR net81 sky130_fd_sc_hd__dlygate4sd3_1
Xhold86 u_uart.busy VGND VGND VPWR VPWR net92 sky130_fd_sc_hd__dlygate4sd3_1
Xhold20 u_uart.shreg\[7\] VGND VGND VPWR VPWR net26 sky130_fd_sc_hd__dlygate4sd3_1
Xhold42 u_uart.tx_data\[2\] VGND VGND VPWR VPWR net48 sky130_fd_sc_hd__dlygate4sd3_1
Xhold31 _0082_ VGND VGND VPWR VPWR net37 sky130_fd_sc_hd__dlygate4sd3_1
XFILLER_0_42_29 VGND VGND VPWR VPWR sky130_fd_sc_hd__fill_2
XFILLER_0_38_232 VPWR VGND VPWR VGND sky130_ef_sc_hd__decap_12
XTAP_349 VGND VPWR sky130_fd_sc_hd__tapvpwrvgnd_1
XTAP_338 VGND VPWR sky130_fd_sc_hd__tapvpwrvgnd_1
XTAP_327 VGND VPWR sky130_fd_sc_hd__tapvpwrvgnd_1
XTAP_316 VGND VPWR sky130_fd_sc_hd__tapvpwrvgnd_1
XTAP_305 VGND VPWR sky130_fd_sc_hd__tapvpwrvgnd_1
XFILLER_0_6_29 VGND VGND VPWR VPWR sky130_fd_sc_hd__decap_4
X_1003_ _0441_ _0450_ VGND VGND VPWR VPWR _0451_ sky130_fd_sc_hd__or2_1
XFILLER_0_16_41 VPWR VGND VPWR VGND sky130_ef_sc_hd__decap_12
XFILLER_0_8_159 VPWR VGND VPWR VGND sky130_ef_sc_hd__decap_12
XFILLER_0_29_210 VPWR VGND VPWR VGND sky130_ef_sc_hd__decap_12
XFILLER_0_12_110 VGND VGND VPWR VPWR sky130_fd_sc_hd__decap_6
X_0718_ _0160_ _0159_ _0236_ VGND VGND VPWR VPWR _0019_ sky130_fd_sc_hd__a21oi_1
X_0649_ bit_idx\[2\] bit_idx\[1\] bit_idx\[0\] VGND VGND VPWR VPWR _0179_ sky130_fd_sc_hd__or3_1
XFILLER_0_35_279 VGND VGND VPWR VPWR sky130_fd_sc_hd__fill_1
XFILLER_0_26_213 VGND VGND VPWR VPWR sky130_fd_sc_hd__decap_4
XFILLER_0_41_216 VGND VGND VPWR VPWR sky130_fd_sc_hd__decap_8
XTAP_135 VGND VPWR sky130_fd_sc_hd__tapvpwrvgnd_1
XTAP_124 VGND VPWR sky130_fd_sc_hd__tapvpwrvgnd_1
XTAP_102 VGND VPWR sky130_fd_sc_hd__tapvpwrvgnd_1
XTAP_113 VGND VPWR sky130_fd_sc_hd__tapvpwrvgnd_1
XTAP_146 VGND VPWR sky130_fd_sc_hd__tapvpwrvgnd_1
XTAP_157 VGND VPWR sky130_fd_sc_hd__tapvpwrvgnd_1
XTAP_168 VGND VPWR sky130_fd_sc_hd__tapvpwrvgnd_1
XTAP_179 VGND VPWR sky130_fd_sc_hd__tapvpwrvgnd_1
XFILLER_0_27_40 VPWR VGND VPWR VGND sky130_ef_sc_hd__decap_12
XFILLER_0_27_62 VPWR VGND VPWR VGND sky130_ef_sc_hd__decap_12
XFILLER_0_4_195 VGND VGND VPWR VPWR sky130_fd_sc_hd__fill_1
X_0983_ _0431_ _0432_ _0433_ _0435_ VGND VGND VPWR VPWR _0436_ sky130_fd_sc_hd__or4_2
XFILLER_0_9_210 VGND VGND VPWR VPWR sky130_fd_sc_hd__fill_1
X_1320_ clknet_4_2_0_clk _0102_ VGND VGND VPWR VPWR u_uart.clk_cnt\[4\] sky130_fd_sc_hd__dfxtp_1
X_1182_ _0582_ VGND VGND VPWR VPWR _0137_ sky130_fd_sc_hd__clkbuf_1
X_1251_ clknet_4_2_0_clk _0035_ VGND VGND VPWR VPWR warm\[13\] sky130_fd_sc_hd__dfxtp_1
XFILLER_0_46_105 VGND VGND VPWR VPWR sky130_fd_sc_hd__fill_1
XFILLER_0_24_85 VGND VGND VPWR VPWR sky130_fd_sc_hd__decap_8
X_0897_ _0365_ _0366_ VGND VGND VPWR VPWR _0367_ sky130_fd_sc_hd__and2b_1
X_0966_ _0201_ _0232_ _0420_ VGND VGND VPWR VPWR _0421_ sky130_fd_sc_hd__and3_1
XFILLER_0_37_138 VPWR VGND VPWR VGND sky130_ef_sc_hd__decap_12
X_0820_ u_apt.idx\[2\] _0305_ VGND VGND VPWR VPWR _0308_ sky130_fd_sc_hd__or2_1
X_0751_ net15 warm\[6\] _0254_ VGND VGND VPWR VPWR _0260_ sky130_fd_sc_hd__and3_1
X_0682_ u_apt.rst_n VGND VGND VPWR VPWR _0206_ sky130_fd_sc_hd__clkbuf_4
X_1303_ clknet_4_8_0_clk _0085_ VGND VGND VPWR VPWR u_uart.busy sky130_fd_sc_hd__dfxtp_2
X_1165_ _0568_ _0535_ _0569_ VGND VGND VPWR VPWR _0570_ sky130_fd_sc_hd__and3b_1
X_1096_ net12 _0517_ _0519_ _0239_ VGND VGND VPWR VPWR _0114_ sky130_fd_sc_hd__a211o_1
X_1234_ clknet_4_9_0_clk _0019_ VGND VGND VPWR VPWR tx_pending sky130_fd_sc_hd__dfxtp_1
XFILLER_0_42_185 VGND VGND VPWR VPWR sky130_fd_sc_hd__decap_8
X_0949_ u_apt.cnt\[15\] _0374_ VGND VGND VPWR VPWR _0407_ sky130_fd_sc_hd__nor2_1
XFILLER_0_33_163 VGND VGND VPWR VPWR sky130_fd_sc_hd__decap_4
XFILLER_0_33_185 VGND VGND VPWR VPWR sky130_fd_sc_hd__fill_1
X_0803_ u_rct.cnt\[5\] _0270_ _0296_ net101 VGND VGND VPWR VPWR _0297_ sky130_fd_sc_hd__a31o_1
X_0734_ warm\[3\] warm\[2\] _0241_ VGND VGND VPWR VPWR _0247_ sky130_fd_sc_hd__and3_1
XFILLER_0_24_141 VGND VGND VPWR VPWR sky130_fd_sc_hd__decap_6
X_0665_ _0175_ _0192_ VGND VGND VPWR VPWR _0193_ sky130_fd_sc_hd__and2_1
XFILLER_0_47_222 VGND VGND VPWR VPWR sky130_fd_sc_hd__fill_2
X_1148_ _0557_ VGND VGND VPWR VPWR _0128_ sky130_fd_sc_hd__clkbuf_1
X_1079_ u_uart.clk_cnt\[11\] _0437_ _0497_ _0505_ VGND VGND VPWR VPWR _0507_ sky130_fd_sc_hd__and4_1
X_1217_ clknet_4_11_0_clk net49 VGND VGND VPWR VPWR u_uart.tx_data\[2\] sky130_fd_sc_hd__dfxtp_1
XFILLER_0_15_152 VPWR VGND VPWR VGND sky130_ef_sc_hd__decap_12
Xhold76 div\[20\] VGND VGND VPWR VPWR net82 sky130_fd_sc_hd__dlygate4sd3_1
Xhold65 warm\[10\] VGND VGND VPWR VPWR net71 sky130_fd_sc_hd__dlygate4sd3_1
Xu_ro_bank.g_ro\[5\].u_ro.g_stg\[7\].u_inv_u_cell u_ro_bank.g_ro\[5\].u_ro.n\[6\]
+ VGND VGND VPWR VPWR u_ro_bank.g_ro\[5\].u_ro.n\[7\] sky130_fd_sc_hd__inv_1
Xhold21 u_uart.shreg\[6\] VGND VGND VPWR VPWR net27 sky130_fd_sc_hd__dlygate4sd3_1
Xhold98 u_uart.clk_cnt\[11\] VGND VGND VPWR VPWR net104 sky130_fd_sc_hd__dlygate4sd3_1
Xhold54 u_uart.clk_cnt\[1\] VGND VGND VPWR VPWR net60 sky130_fd_sc_hd__dlygate4sd3_1
Xhold10 _0029_ VGND VGND VPWR VPWR net16 sky130_fd_sc_hd__dlygate4sd3_1
Xhold32 u_uart.clk_cnt\[15\] VGND VGND VPWR VPWR net38 sky130_fd_sc_hd__dlygate4sd3_1
Xhold43 _0002_ VGND VGND VPWR VPWR net49 sky130_fd_sc_hd__dlygate4sd3_1
Xhold87 div\[9\] VGND VGND VPWR VPWR net93 sky130_fd_sc_hd__dlygate4sd3_1
XFILLER_0_21_100 VGND VGND VPWR VPWR sky130_fd_sc_hd__decap_6
XTAP_339 VGND VPWR sky130_fd_sc_hd__tapvpwrvgnd_1
XTAP_328 VGND VPWR sky130_fd_sc_hd__tapvpwrvgnd_1
XTAP_317 VGND VPWR sky130_fd_sc_hd__tapvpwrvgnd_1
XTAP_306 VGND VPWR sky130_fd_sc_hd__tapvpwrvgnd_1
X_1002_ u_uart.tx_data\[4\] u_uart.shreg\[5\] _0424_ VGND VGND VPWR VPWR _0450_ sky130_fd_sc_hd__mux2_1
XFILLER_0_16_53 VGND VGND VPWR VPWR sky130_fd_sc_hd__fill_1
XFILLER_0_16_64 VPWR VGND VPWR VGND sky130_ef_sc_hd__decap_12
XFILLER_0_29_222 VGND VGND VPWR VPWR sky130_fd_sc_hd__fill_2
XFILLER_0_32_41 VGND VGND VPWR VPWR sky130_fd_sc_hd__decap_6
X_0648_ _0177_ _0158_ _0155_ VGND VGND VPWR VPWR _0178_ sky130_fd_sc_hd__o21a_1
X_0717_ _0235_ VGND VGND VPWR VPWR _0236_ sky130_fd_sc_hd__clkbuf_4
XFILLER_0_35_225 VPWR VGND VPWR VGND sky130_ef_sc_hd__decap_12
Xclkbuf_4_10_0_clk clknet_0_clk VGND VGND VPWR VPWR clknet_4_10_0_clk sky130_fd_sc_hd__clkbuf_8
XFILLER_0_26_258 VGND VGND VPWR VPWR sky130_fd_sc_hd__fill_2
XFILLER_0_26_269 VGND VGND VPWR VPWR sky130_fd_sc_hd__decap_4
XFILLER_0_41_228 VGND VGND VPWR VPWR sky130_fd_sc_hd__decap_3
XTAP_114 VGND VPWR sky130_fd_sc_hd__tapvpwrvgnd_1
XTAP_103 VGND VPWR sky130_fd_sc_hd__tapvpwrvgnd_1
XTAP_136 VGND VPWR sky130_fd_sc_hd__tapvpwrvgnd_1
XTAP_125 VGND VPWR sky130_fd_sc_hd__tapvpwrvgnd_1
XTAP_147 VGND VPWR sky130_fd_sc_hd__tapvpwrvgnd_1
XTAP_158 VGND VPWR sky130_fd_sc_hd__tapvpwrvgnd_1
XTAP_169 VGND VPWR sky130_fd_sc_hd__tapvpwrvgnd_1
XFILLER_0_27_52 VGND VGND VPWR VPWR sky130_fd_sc_hd__decap_4
XFILLER_0_27_74 VGND VGND VPWR VPWR sky130_fd_sc_hd__decap_8
XFILLER_0_43_84 VPWR VGND VPWR VGND sky130_ef_sc_hd__decap_12
XFILLER_0_4_141 VGND VGND VPWR VPWR sky130_fd_sc_hd__fill_2
XFILLER_0_48_29 VPWR VGND VPWR VGND sky130_ef_sc_hd__decap_12
X_0982_ _0434_ u_uart.clk_cnt\[4\] u_uart.clk_cnt\[3\] u_uart.clk_cnt\[2\] VGND VGND
+ VPWR VPWR _0435_ sky130_fd_sc_hd__or4_1
XFILLER_0_1_111 VGND VGND VPWR VPWR sky130_fd_sc_hd__fill_1
XFILLER_0_1_133 VGND VGND VPWR VPWR sky130_fd_sc_hd__fill_1
XFILLER_0_22_250 VGND VGND VPWR VPWR sky130_fd_sc_hd__fill_2
XFILLER_0_9_255 VGND VGND VPWR VPWR sky130_fd_sc_hd__decap_3
Xu_ro_bank.g_ro\[4\].u_ro.g_stg\[3\].u_inv_u_cell u_ro_bank.g_ro\[4\].u_ro.n\[2\]
+ VGND VGND VPWR VPWR u_ro_bank.g_ro\[4\].u_ro.n\[3\] sky130_fd_sc_hd__inv_1
X_1181_ _0524_ _0580_ _0581_ VGND VGND VPWR VPWR _0582_ sky130_fd_sc_hd__and3_1
X_1250_ clknet_4_2_0_clk _0034_ VGND VGND VPWR VPWR warm\[12\] sky130_fd_sc_hd__dfxtp_1
XFILLER_0_6_225 VPWR VGND VPWR VGND sky130_ef_sc_hd__decap_12
X_0896_ u_apt.cnt\[2\] u_apt.cnt\[1\] u_apt.cnt\[0\] u_apt.cnt\[3\] VGND VGND VPWR
+ VPWR _0366_ sky130_fd_sc_hd__a31o_1
XFILLER_0_40_85 VGND VGND VPWR VPWR sky130_fd_sc_hd__decap_3
XFILLER_0_40_52 VGND VGND VPWR VPWR sky130_fd_sc_hd__fill_2
XFILLER_0_40_41 VGND VGND VPWR VPWR sky130_fd_sc_hd__decap_4
X_0965_ _0214_ _0231_ VGND VGND VPWR VPWR _0420_ sky130_fd_sc_hd__nand2_1
XFILLER_0_4_85 VPWR VGND VPWR VGND sky130_ef_sc_hd__decap_12
XFILLER_0_28_117 VGND VGND VPWR VPWR sky130_fd_sc_hd__decap_3
XFILLER_0_36_194 VGND VGND VPWR VPWR sky130_fd_sc_hd__fill_2
X_0750_ _0259_ VGND VGND VPWR VPWR _0028_ sky130_fd_sc_hd__clkbuf_1
X_0681_ bit_idx\[2\] _0157_ _0155_ net77 VGND VGND VPWR VPWR _0205_ sky130_fd_sc_hd__a31o_1
X_1233_ clknet_4_12_0_clk _0018_ VGND VGND VPWR VPWR u_vn.ov sky130_fd_sc_hd__dfxtp_1
X_1302_ clknet_4_12_0_clk _0084_ VGND VGND VPWR VPWR u_vn.o sky130_fd_sc_hd__dfxtp_1
X_1164_ div\[18\] _0565_ VGND VGND VPWR VPWR _0569_ sky130_fd_sc_hd__or2_1
XFILLER_0_35_63 VGND VGND VPWR VPWR sky130_fd_sc_hd__decap_4
X_1095_ u_uart.shreg\[0\] _0518_ _0469_ _0430_ _0473_ VGND VGND VPWR VPWR _0519_ sky130_fd_sc_hd__o2111a_1
XFILLER_0_42_120 VPWR VGND VPWR VGND sky130_ef_sc_hd__decap_12
X_0948_ _0406_ VGND VGND VPWR VPWR _0079_ sky130_fd_sc_hd__clkbuf_1
XFILLER_0_42_197 VPWR VGND VPWR VGND sky130_ef_sc_hd__decap_12
X_0879_ _0351_ VGND VGND VPWR VPWR _0352_ sky130_fd_sc_hd__inv_2
XFILLER_0_2_250 VGND VGND VPWR VPWR sky130_fd_sc_hd__fill_2
XFILLER_0_0_209 VPWR VGND VPWR VGND sky130_ef_sc_hd__decap_12
X_0802_ _0229_ _0295_ VGND VGND VPWR VPWR _0296_ sky130_fd_sc_hd__nor2_2
X_0733_ _0246_ VGND VGND VPWR VPWR _0024_ sky130_fd_sc_hd__clkbuf_1
XFILLER_0_24_197 VGND VGND VPWR VPWR sky130_fd_sc_hd__decap_8
X_0664_ byte_reg\[2\] _0176_ _0178_ _0191_ VGND VGND VPWR VPWR _0192_ sky130_fd_sc_hd__a22o_1
Xu_ro_bank.g_ro\[7\].u_ro.g_stg\[15\].u_inv_u_cell u_ro_bank.g_ro\[7\].u_ro.n\[14\]
+ VGND VGND VPWR VPWR u_ro_bank.g_ro\[7\].u_ro.n\[15\] sky130_fd_sc_hd__inv_1
X_1216_ clknet_4_11_0_clk net47 VGND VGND VPWR VPWR u_uart.tx_data\[1\] sky130_fd_sc_hd__dfxtp_1
X_1147_ _0555_ _0535_ _0556_ VGND VGND VPWR VPWR _0557_ sky130_fd_sc_hd__and3b_1
X_1078_ _0437_ _0505_ _0457_ VGND VGND VPWR VPWR _0506_ sky130_fd_sc_hd__a21o_1
XFILLER_0_47_289 VGND VGND VPWR VPWR sky130_fd_sc_hd__fill_2
XFILLER_0_15_164 VGND VGND VPWR VPWR sky130_fd_sc_hd__decap_4
XFILLER_0_15_175 VGND VGND VPWR VPWR sky130_fd_sc_hd__fill_1
Xhold22 u_uart.shreg\[4\] VGND VGND VPWR VPWR net28 sky130_fd_sc_hd__dlygate4sd3_1
Xhold11 u_uart.tx_data\[7\] VGND VGND VPWR VPWR net17 sky130_fd_sc_hd__dlygate4sd3_1
Xhold77 _0135_ VGND VGND VPWR VPWR net83 sky130_fd_sc_hd__dlygate4sd3_1
Xhold55 u_apt.rst_n VGND VGND VPWR VPWR net61 sky130_fd_sc_hd__dlygate4sd3_1
Xhold66 warm\[12\] VGND VGND VPWR VPWR net72 sky130_fd_sc_hd__dlygate4sd3_1
Xhold44 u_uart.clk_cnt\[10\] VGND VGND VPWR VPWR net50 sky130_fd_sc_hd__dlygate4sd3_1
Xhold33 _0113_ VGND VGND VPWR VPWR net39 sky130_fd_sc_hd__dlygate4sd3_1
Xhold88 u_uart.clk_cnt\[13\] VGND VGND VPWR VPWR net94 sky130_fd_sc_hd__dlygate4sd3_1
XFILLER_0_38_289 VGND VGND VPWR VPWR sky130_fd_sc_hd__fill_2
XFILLER_0_38_256 VGND VGND VPWR VPWR sky130_fd_sc_hd__decap_8
XFILLER_0_38_223 VGND VGND VPWR VPWR sky130_fd_sc_hd__fill_2
XFILLER_0_21_167 VGND VGND VPWR VPWR sky130_fd_sc_hd__fill_1
XFILLER_0_21_189 VGND VGND VPWR VPWR sky130_fd_sc_hd__fill_1
XTAP_329 VGND VPWR sky130_fd_sc_hd__tapvpwrvgnd_1
XTAP_318 VGND VPWR sky130_fd_sc_hd__tapvpwrvgnd_1
XTAP_307 VGND VPWR sky130_fd_sc_hd__tapvpwrvgnd_1
X_1001_ net21 _0440_ _0449_ _0372_ VGND VGND VPWR VPWR _0089_ sky130_fd_sc_hd__o211a_1
XFILLER_0_16_76 VGND VGND VPWR VPWR sky130_fd_sc_hd__fill_2
XFILLER_0_12_101 VGND VGND VPWR VPWR sky130_fd_sc_hd__fill_1
XFILLER_0_29_289 VGND VGND VPWR VPWR sky130_fd_sc_hd__fill_2
X_0647_ bit_idx\[0\] VGND VGND VPWR VPWR _0177_ sky130_fd_sc_hd__inv_2
X_0716_ u_apt.rst_n VGND VGND VPWR VPWR _0235_ sky130_fd_sc_hd__inv_2
XFILLER_0_32_3 VGND VGND VPWR VPWR sky130_fd_sc_hd__decap_8
XFILLER_0_35_237 VGND VGND VPWR VPWR sky130_fd_sc_hd__decap_8
XFILLER_0_43_281 VGND VGND VPWR VPWR sky130_fd_sc_hd__decap_8
XFILLER_0_7_183 VPWR VGND VPWR VGND sky130_ef_sc_hd__decap_12
XFILLER_0_34_270 VGND VGND VPWR VPWR sky130_fd_sc_hd__fill_1
XFILLER_0_5_109 VGND VGND VPWR VPWR sky130_fd_sc_hd__decap_3
XTAP_137 VGND VPWR sky130_fd_sc_hd__tapvpwrvgnd_1
XTAP_126 VGND VPWR sky130_fd_sc_hd__tapvpwrvgnd_1
XTAP_115 VGND VPWR sky130_fd_sc_hd__tapvpwrvgnd_1
XTAP_104 VGND VPWR sky130_fd_sc_hd__tapvpwrvgnd_1
XTAP_148 VGND VPWR sky130_fd_sc_hd__tapvpwrvgnd_1
XTAP_159 VGND VPWR sky130_fd_sc_hd__tapvpwrvgnd_1
XFILLER_0_43_96 VGND VGND VPWR VPWR sky130_fd_sc_hd__decap_8
XFILLER_0_43_52 VGND VGND VPWR VPWR sky130_fd_sc_hd__decap_4
XFILLER_0_40_251 VGND VGND VPWR VPWR sky130_fd_sc_hd__fill_1
XFILLER_0_4_197 VGND VGND VPWR VPWR sky130_fd_sc_hd__fill_1
XFILLER_0_25_281 VGND VGND VPWR VPWR sky130_fd_sc_hd__decap_6
XFILLER_0_40_273 VPWR VGND VPWR VGND sky130_ef_sc_hd__decap_12
Xu_ro_bank.g_ro\[4\].u_ro.g_stg\[10\].u_inv_u_cell u_ro_bank.g_ro\[4\].u_ro.n\[9\]
+ VGND VGND VPWR VPWR u_ro_bank.g_ro\[4\].u_ro.n\[10\] sky130_fd_sc_hd__inv_1
X_0981_ net56 VGND VGND VPWR VPWR _0434_ sky130_fd_sc_hd__inv_2
XFILLER_0_38_63 VGND VGND VPWR VPWR sky130_fd_sc_hd__decap_4
XFILLER_0_1_167 VGND VGND VPWR VPWR sky130_fd_sc_hd__fill_1
XFILLER_0_9_267 VGND VGND VPWR VPWR sky130_fd_sc_hd__decap_4
XFILLER_0_9_289 VGND VGND VPWR VPWR sky130_fd_sc_hd__fill_2
XFILLER_0_48_181 VPWR VGND VPWR VGND sky130_ef_sc_hd__decap_12
X_1180_ div\[22\] _0577_ VGND VGND VPWR VPWR _0581_ sky130_fd_sc_hd__nand2_1
XFILLER_0_46_129 VGND VGND VPWR VPWR sky130_fd_sc_hd__decap_8
XFILLER_0_39_181 VGND VGND VPWR VPWR sky130_fd_sc_hd__decap_4
XFILLER_0_6_237 VPWR VGND VPWR VGND sky130_ef_sc_hd__decap_12
X_0964_ net36 _0299_ _0419_ _0372_ VGND VGND VPWR VPWR _0082_ sky130_fd_sc_hd__o211a_1
X_0895_ u_apt.cnt\[3\] u_apt.cnt\[2\] u_apt.cnt\[1\] u_apt.cnt\[0\] VGND VGND VPWR
+ VPWR _0365_ sky130_fd_sc_hd__and4_2
XFILLER_0_4_97 VPWR VGND VPWR VGND sky130_ef_sc_hd__decap_12
XFILLER_0_4_42 VPWR VGND VPWR VGND sky130_ef_sc_hd__decap_12
XFILLER_0_10_287 VGND VGND VPWR VPWR sky130_fd_sc_hd__decap_4
XFILLER_0_5_281 VGND VGND VPWR VPWR sky130_fd_sc_hd__decap_8
XFILLER_0_10_78 VGND VGND VPWR VPWR sky130_fd_sc_hd__decap_6
X_0680_ _0204_ VGND VGND VPWR VPWR _0013_ sky130_fd_sc_hd__clkbuf_1
Xu_ro_bank.g_ro\[6\].u_ro.g_stg\[7\].u_inv_u_cell u_ro_bank.g_ro\[6\].u_ro.n\[6\]
+ VGND VGND VPWR VPWR u_ro_bank.g_ro\[6\].u_ro.n\[7\] sky130_fd_sc_hd__inv_1
X_1232_ clknet_4_9_0_clk _0017_ VGND VGND VPWR VPWR bit_idx\[2\] sky130_fd_sc_hd__dfxtp_2
X_1301_ clknet_4_9_0_clk _0083_ VGND VGND VPWR VPWR u_vn.have sky130_fd_sc_hd__dfxtp_1
X_1163_ div\[18\] _0565_ VGND VGND VPWR VPWR _0568_ sky130_fd_sc_hd__and2_1
X_1094_ _0426_ _0437_ VGND VGND VPWR VPWR _0518_ sky130_fd_sc_hd__nand2_1
XFILLER_0_19_107 VGND VGND VPWR VPWR sky130_fd_sc_hd__decap_4
XFILLER_0_42_132 VGND VGND VPWR VPWR sky130_fd_sc_hd__decap_8
X_0947_ _0201_ _0404_ _0405_ VGND VGND VPWR VPWR _0406_ sky130_fd_sc_hd__and3_1
XFILLER_0_27_140 VPWR VGND VPWR VGND sky130_ef_sc_hd__decap_12
X_0878_ _0348_ _0350_ _0230_ VGND VGND VPWR VPWR _0351_ sky130_fd_sc_hd__a21o_1
Xu_ro_bank.g_ro\[6\].u_ro.g_stg\[12\].u_inv_u_cell u_ro_bank.g_ro\[6\].u_ro.n\[11\]
+ VGND VGND VPWR VPWR u_ro_bank.g_ro\[6\].u_ro.n\[12\] sky130_fd_sc_hd__inv_1
X_0801_ _0218_ _0221_ _0294_ VGND VGND VPWR VPWR _0295_ sky130_fd_sc_hd__or3_1
XFILLER_0_21_55 VGND VGND VPWR VPWR sky130_fd_sc_hd__fill_1
X_0732_ _0244_ _0165_ _0245_ VGND VGND VPWR VPWR _0246_ sky130_fd_sc_hd__and3b_1
X_0663_ _0189_ _0185_ _0190_ byte_reg\[2\] VGND VGND VPWR VPWR _0191_ sky130_fd_sc_hd__a22o_1
X_1146_ div\[11\] div\[12\] _0548_ div\[13\] VGND VGND VPWR VPWR _0556_ sky130_fd_sc_hd__a31o_1
X_1215_ clknet_4_11_0_clk net45 VGND VGND VPWR VPWR u_uart.tx_data\[0\] sky130_fd_sc_hd__dfxtp_1
XFILLER_0_47_279 VGND VGND VPWR VPWR sky130_fd_sc_hd__fill_1
X_1077_ _0504_ VGND VGND VPWR VPWR _0505_ sky130_fd_sc_hd__inv_2
XFILLER_0_15_110 VGND VGND VPWR VPWR sky130_fd_sc_hd__fill_2
Xhold12 u_apt.idx\[3\] VGND VGND VPWR VPWR net18 sky130_fd_sc_hd__dlygate4sd3_1
Xhold34 u_apt.idx\[4\] VGND VGND VPWR VPWR net40 sky130_fd_sc_hd__dlygate4sd3_1
Xhold56 u_uart.clk_cnt\[3\] VGND VGND VPWR VPWR net62 sky130_fd_sc_hd__dlygate4sd3_1
Xhold23 u_uart.shreg\[2\] VGND VGND VPWR VPWR net29 sky130_fd_sc_hd__dlygate4sd3_1
Xhold45 warm\[0\] VGND VGND VPWR VPWR net51 sky130_fd_sc_hd__dlygate4sd3_1
Xhold78 div\[16\] VGND VGND VPWR VPWR net84 sky130_fd_sc_hd__dlygate4sd3_1
Xhold89 u_rct.cnt\[7\] VGND VGND VPWR VPWR net95 sky130_fd_sc_hd__dlygate4sd3_1
Xhold67 byte_reg\[1\] VGND VGND VPWR VPWR net73 sky130_fd_sc_hd__dlygate4sd3_1
XTAP_319 VGND VPWR sky130_fd_sc_hd__tapvpwrvgnd_1
XTAP_308 VGND VPWR sky130_fd_sc_hd__tapvpwrvgnd_1
XFILLER_0_21_113 VGND VGND VPWR VPWR sky130_fd_sc_hd__decap_3
X_1000_ _0441_ _0448_ VGND VGND VPWR VPWR _0449_ sky130_fd_sc_hd__or2_1
XFILLER_0_29_279 VGND VGND VPWR VPWR sky130_fd_sc_hd__fill_1
XFILLER_0_44_238 VPWR VGND VPWR VGND sky130_ef_sc_hd__decap_12
X_0715_ _0234_ VGND VGND VPWR VPWR _0018_ sky130_fd_sc_hd__clkbuf_1
XFILLER_0_12_157 VGND VGND VPWR VPWR sky130_fd_sc_hd__fill_2
X_0646_ _0154_ net4 VGND VGND VPWR VPWR _0176_ sky130_fd_sc_hd__or2_2
XFILLER_0_25_3 VPWR VGND VPWR VGND sky130_ef_sc_hd__decap_12
X_1129_ _0543_ _0540_ VGND VGND VPWR VPWR _0544_ sky130_fd_sc_hd__nand2_1
XFILLER_0_35_249 VGND VGND VPWR VPWR sky130_fd_sc_hd__fill_1
XFILLER_0_7_195 VPWR VGND VPWR VGND sky130_ef_sc_hd__decap_12
Xu_ro_bank.g_ro\[5\].u_ro.g_stg\[3\].u_inv_u_cell u_ro_bank.g_ro\[5\].u_ro.n\[2\]
+ VGND VGND VPWR VPWR u_ro_bank.g_ro\[5\].u_ro.n\[3\] sky130_fd_sc_hd__inv_1
XFILLER_0_26_238 VGND VGND VPWR VPWR sky130_fd_sc_hd__fill_1
XTAP_138 VGND VPWR sky130_fd_sc_hd__tapvpwrvgnd_1
XTAP_127 VGND VPWR sky130_fd_sc_hd__tapvpwrvgnd_1
XTAP_116 VGND VPWR sky130_fd_sc_hd__tapvpwrvgnd_1
XTAP_105 VGND VPWR sky130_fd_sc_hd__tapvpwrvgnd_1
XTAP_149 VGND VPWR sky130_fd_sc_hd__tapvpwrvgnd_1
XFILLER_0_27_87 VPWR VGND VPWR VGND sky130_ef_sc_hd__decap_12
XFILLER_0_43_42 VGND VGND VPWR VPWR sky130_fd_sc_hd__decap_3
XFILLER_0_17_249 VGND VGND VPWR VPWR sky130_fd_sc_hd__decap_3
XFILLER_0_40_285 VGND VGND VPWR VPWR sky130_fd_sc_hd__decap_6
XFILLER_0_7_42 VGND VGND VPWR VPWR sky130_fd_sc_hd__fill_1
XFILLER_0_4_187 VGND VGND VPWR VPWR sky130_fd_sc_hd__decap_8
XFILLER_0_4_121 VPWR VGND VPWR VGND sky130_ef_sc_hd__decap_12
X_0629_ net44 _0162_ _0164_ _0166_ VGND VGND VPWR VPWR _0000_ sky130_fd_sc_hd__o211a_1
XFILLER_0_23_219 VGND VGND VPWR VPWR sky130_fd_sc_hd__fill_1
X_0980_ u_uart.clk_cnt\[11\] u_uart.clk_cnt\[10\] u_uart.clk_cnt\[7\] u_uart.clk_cnt\[6\]
+ VGND VGND VPWR VPWR _0433_ sky130_fd_sc_hd__or4b_1
XFILLER_0_1_113 VPWR VGND VPWR VGND sky130_ef_sc_hd__decap_12
XFILLER_0_14_208 VPWR VGND VPWR VGND sky130_ef_sc_hd__decap_12
XFILLER_0_48_193 VGND VGND VPWR VPWR sky130_fd_sc_hd__decap_3
XFILLER_0_39_193 VGND VGND VPWR VPWR sky130_fd_sc_hd__decap_8
X_0894_ _0364_ VGND VGND VPWR VPWR _0067_ sky130_fd_sc_hd__clkbuf_1
XFILLER_0_6_249 VGND VGND VPWR VPWR sky130_fd_sc_hd__decap_3
X_0963_ _0214_ _0296_ u_vn.first VGND VGND VPWR VPWR _0419_ sky130_fd_sc_hd__a21o_1
XFILLER_0_10_222 VGND VGND VPWR VPWR sky130_fd_sc_hd__decap_3
XFILLER_0_10_233 VGND VGND VPWR VPWR sky130_fd_sc_hd__fill_2
XFILLER_0_4_54 VPWR VGND VPWR VGND sky130_ef_sc_hd__decap_12
XFILLER_0_4_21 VGND VGND VPWR VPWR sky130_fd_sc_hd__fill_1
X_1162_ _0567_ VGND VGND VPWR VPWR _0132_ sky130_fd_sc_hd__clkbuf_1
X_1300_ clknet_4_12_0_clk net37 VGND VGND VPWR VPWR u_vn.first sky130_fd_sc_hd__dfxtp_1
X_1231_ clknet_4_14_0_clk _0016_ VGND VGND VPWR VPWR bit_idx\[1\] sky130_fd_sc_hd__dfxtp_1
X_1093_ _0430_ _0473_ VGND VGND VPWR VPWR _0517_ sky130_fd_sc_hd__nand2_1
X_0946_ u_apt.cnt\[13\] _0352_ _0399_ u_apt.cnt\[14\] VGND VGND VPWR VPWR _0405_ sky130_fd_sc_hd__a31o_1
XFILLER_0_2_230 VPWR VGND VPWR VGND sky130_ef_sc_hd__decap_12
XFILLER_0_27_152 VGND VGND VPWR VPWR sky130_fd_sc_hd__decap_6
XFILLER_0_27_196 VGND VGND VPWR VPWR sky130_fd_sc_hd__fill_1
X_0877_ u_apt.b u_apt.ref_bit VGND VGND VPWR VPWR _0350_ sky130_fd_sc_hd__xor2_1
XFILLER_0_18_141 VGND VGND VPWR VPWR sky130_fd_sc_hd__fill_2
XFILLER_0_33_122 VGND VGND VPWR VPWR sky130_fd_sc_hd__fill_1
X_0800_ _0222_ _0223_ _0224_ _0225_ VGND VGND VPWR VPWR _0294_ sky130_fd_sc_hd__or4_1
X_0731_ warm\[2\] _0241_ VGND VGND VPWR VPWR _0245_ sky130_fd_sc_hd__or2_1
X_0662_ _0177_ _0185_ VGND VGND VPWR VPWR _0190_ sky130_fd_sc_hd__nand2_1
XFILLER_0_46_64 VPWR VGND VPWR VGND sky130_ef_sc_hd__decap_12
X_1214_ _0605_ VGND VGND VPWR VPWR _0146_ sky130_fd_sc_hd__clkbuf_1
X_1145_ div\[11\] div\[13\] div\[12\] _0548_ VGND VGND VPWR VPWR _0555_ sky130_fd_sc_hd__and4_2
XFILLER_0_27_7 VGND VGND VPWR VPWR sky130_fd_sc_hd__fill_1
XFILLER_0_47_225 VPWR VGND VPWR VGND sky130_ef_sc_hd__decap_12
X_1076_ u_uart.clk_cnt\[12\] u_uart.clk_cnt\[11\] _0497_ VGND VGND VPWR VPWR _0504_
+ sky130_fd_sc_hd__and3_1
X_0929_ net52 _0356_ VGND VGND VPWR VPWR _0392_ sky130_fd_sc_hd__nand2_1
XFILLER_0_30_169 VGND VGND VPWR VPWR sky130_fd_sc_hd__fill_2
XFILLER_0_15_144 VGND VGND VPWR VPWR sky130_fd_sc_hd__fill_2
Xhold79 div\[25\] VGND VGND VPWR VPWR net85 sky130_fd_sc_hd__dlygate4sd3_1
Xhold46 u_apt.cnt\[10\] VGND VGND VPWR VPWR net52 sky130_fd_sc_hd__dlygate4sd3_1
Xhold13 _0051_ VGND VGND VPWR VPWR net19 sky130_fd_sc_hd__dlygate4sd3_1
Xhold35 u_apt.cnt\[12\] VGND VGND VPWR VPWR net41 sky130_fd_sc_hd__dlygate4sd3_1
Xhold57 tx_pending VGND VGND VPWR VPWR net63 sky130_fd_sc_hd__dlygate4sd3_1
Xhold24 u_uart.tx_data\[6\] VGND VGND VPWR VPWR net30 sky130_fd_sc_hd__dlygate4sd3_1
Xhold68 u_apt.idx\[8\] VGND VGND VPWR VPWR net74 sky130_fd_sc_hd__dlygate4sd3_1
XTAP_309 VGND VPWR sky130_fd_sc_hd__tapvpwrvgnd_1
XFILLER_0_21_169 VPWR VGND VPWR VGND sky130_ef_sc_hd__decap_12
XFILLER_0_32_66 VGND VGND VPWR VPWR sky130_fd_sc_hd__decap_4
Xu_ro_bank.g_ro\[0\].u_ro.g_stg\[2\].u_inv_u_cell u_ro_bank.g_ro\[0\].u_ro.n\[1\]
+ VGND VGND VPWR VPWR u_ro_bank.g_ro\[0\].u_ro.n\[2\] sky130_fd_sc_hd__inv_1
XFILLER_0_29_225 VPWR VGND VPWR VGND sky130_ef_sc_hd__decap_12
X_0645_ u_apt.rst_n VGND VGND VPWR VPWR _0175_ sky130_fd_sc_hd__buf_2
X_0714_ _0175_ _0233_ VGND VGND VPWR VPWR _0234_ sky130_fd_sc_hd__and2_1
X_1059_ u_uart.clk_cnt\[7\] _0484_ _0489_ _0490_ u_uart.clk_cnt\[8\] VGND VGND VPWR
+ VPWR _0491_ sky130_fd_sc_hd__a32o_1
XFILLER_0_18_3 VPWR VGND VPWR VGND sky130_ef_sc_hd__decap_12
X_1128_ net97 VGND VGND VPWR VPWR _0543_ sky130_fd_sc_hd__inv_2
XFILLER_0_43_261 VPWR VGND VPWR VGND sky130_ef_sc_hd__decap_12
Xu_ro_bank.g_ro\[7\].u_ro.g_stg\[11\].u_inv_u_cell u_ro_bank.g_ro\[7\].u_ro.n\[10\]
+ VGND VGND VPWR VPWR u_ro_bank.g_ro\[7\].u_ro.n\[11\] sky130_fd_sc_hd__inv_1
XFILLER_0_11_191 VGND VGND VPWR VPWR sky130_fd_sc_hd__decap_4
XFILLER_0_26_217 VGND VGND VPWR VPWR sky130_fd_sc_hd__fill_1
XFILLER_0_26_228 VGND VGND VPWR VPWR sky130_fd_sc_hd__fill_2
XTAP_139 VGND VPWR sky130_fd_sc_hd__tapvpwrvgnd_1
XTAP_128 VGND VPWR sky130_fd_sc_hd__tapvpwrvgnd_1
XTAP_117 VGND VPWR sky130_fd_sc_hd__tapvpwrvgnd_1
XTAP_106 VGND VPWR sky130_fd_sc_hd__tapvpwrvgnd_1
XFILLER_0_43_65 VGND VGND VPWR VPWR sky130_fd_sc_hd__decap_3
XPHY_0 VGND VGND VPWR VPWR sky130_fd_sc_hd__decap_3
XFILLER_0_27_99 VGND VGND VPWR VPWR sky130_fd_sc_hd__decap_6
XFILLER_0_4_133 VGND VGND VPWR VPWR sky130_fd_sc_hd__fill_1
X_0628_ _0165_ VGND VGND VPWR VPWR _0166_ sky130_fd_sc_hd__clkbuf_4
XFILLER_0_7_3 VGND VGND VPWR VPWR sky130_fd_sc_hd__decap_3
XFILLER_0_13_57 VGND VGND VPWR VPWR sky130_fd_sc_hd__decap_4
XFILLER_0_1_125 VGND VGND VPWR VPWR sky130_fd_sc_hd__decap_8
XFILLER_0_1_169 VGND VGND VPWR VPWR sky130_fd_sc_hd__decap_6
XFILLER_0_22_220 VPWR VGND VPWR VGND sky130_ef_sc_hd__decap_12
Xu_ro_bank.g_ro\[7\].u_ro.g_stg\[7\].u_inv_u_cell u_ro_bank.g_ro\[7\].u_ro.n\[6\]
+ VGND VGND VPWR VPWR u_ro_bank.g_ro\[7\].u_ro.n\[7\] sky130_fd_sc_hd__inv_1
XFILLER_0_39_161 VGND VGND VPWR VPWR sky130_fd_sc_hd__fill_1
X_0893_ _0175_ _0363_ VGND VGND VPWR VPWR _0364_ sky130_fd_sc_hd__and2_1
X_0962_ net10 _0418_ _0166_ VGND VGND VPWR VPWR _0081_ sky130_fd_sc_hd__o21a_1
XFILLER_0_4_66 VPWR VGND VPWR VGND sky130_ef_sc_hd__decap_12
XFILLER_0_5_261 VPWR VGND VPWR VGND sky130_ef_sc_hd__decap_12
XFILLER_0_36_186 VGND VGND VPWR VPWR sky130_fd_sc_hd__decap_8
XFILLER_0_19_45 VGND VGND VPWR VPWR sky130_fd_sc_hd__fill_1
X_1161_ _0565_ _0535_ _0566_ VGND VGND VPWR VPWR _0567_ sky130_fd_sc_hd__and3b_1
XFILLER_0_35_44 VGND VGND VPWR VPWR sky130_fd_sc_hd__decap_6
X_1092_ _0514_ _0512_ _0515_ _0516_ _0239_ VGND VGND VPWR VPWR _0113_ sky130_fd_sc_hd__a221oi_1
X_1230_ clknet_4_14_0_clk _0015_ VGND VGND VPWR VPWR bit_idx\[0\] sky130_fd_sc_hd__dfxtp_2
X_0945_ _0352_ _0403_ VGND VGND VPWR VPWR _0404_ sky130_fd_sc_hd__nand2_1
XFILLER_0_2_253 VPWR VGND VPWR VGND sky130_ef_sc_hd__decap_12
XFILLER_0_2_242 VGND VGND VPWR VPWR sky130_fd_sc_hd__decap_8
X_0876_ _0299_ _0348_ _0349_ net53 _0206_ VGND VGND VPWR VPWR _0064_ sky130_fd_sc_hd__o221a_1
XFILLER_0_48_3 VPWR VGND VPWR VGND sky130_ef_sc_hd__decap_12
X_1359_ clknet_4_7_0_clk _0141_ VGND VGND VPWR VPWR div\[26\] sky130_fd_sc_hd__dfxtp_1
XFILLER_0_18_120 VPWR VGND VPWR VGND sky130_ef_sc_hd__decap_12
XFILLER_0_18_197 VPWR VGND VPWR VGND sky130_ef_sc_hd__decap_12
XFILLER_0_33_167 VGND VGND VPWR VPWR sky130_fd_sc_hd__fill_1
X_0730_ warm\[2\] _0241_ VGND VGND VPWR VPWR _0244_ sky130_fd_sc_hd__and2_1
XFILLER_0_21_79 VGND VGND VPWR VPWR sky130_fd_sc_hd__fill_1
X_0661_ _0188_ bit_idx\[0\] VGND VGND VPWR VPWR _0189_ sky130_fd_sc_hd__nor2_1
X_1213_ _0524_ _0603_ _0604_ VGND VGND VPWR VPWR _0605_ sky130_fd_sc_hd__and3_1
XFILLER_0_46_76 VGND VGND VPWR VPWR sky130_fd_sc_hd__fill_2
X_1144_ net78 _0551_ _0554_ VGND VGND VPWR VPWR _0127_ sky130_fd_sc_hd__o21a_1
X_1075_ _0236_ _0503_ VGND VGND VPWR VPWR _0109_ sky130_fd_sc_hd__nor2_1
XFILLER_0_47_237 VPWR VGND VPWR VGND sky130_ef_sc_hd__decap_12
X_0928_ u_apt.cnt\[9\] _0388_ _0390_ _0391_ _0206_ VGND VGND VPWR VPWR _0074_ sky130_fd_sc_hd__o221a_1
Xu_ro_bank.g_ro\[6\].u_ro.g_stg\[3\].u_inv_u_cell u_ro_bank.g_ro\[6\].u_ro.n\[2\]
+ VGND VGND VPWR VPWR u_ro_bank.g_ro\[6\].u_ro.n\[3\] sky130_fd_sc_hd__inv_1
X_0859_ _0335_ _0251_ _0336_ VGND VGND VPWR VPWR _0337_ sky130_fd_sc_hd__and3b_1
Xhold36 _0077_ VGND VGND VPWR VPWR net42 sky130_fd_sc_hd__dlygate4sd3_1
Xhold58 warm\[11\] VGND VGND VPWR VPWR net64 sky130_fd_sc_hd__dlygate4sd3_1
Xhold69 warm\[9\] VGND VGND VPWR VPWR net75 sky130_fd_sc_hd__dlygate4sd3_1
Xhold14 u_uart.shreg\[5\] VGND VGND VPWR VPWR net20 sky130_fd_sc_hd__dlygate4sd3_1
Xhold25 _0006_ VGND VGND VPWR VPWR net31 sky130_fd_sc_hd__dlygate4sd3_1
Xhold47 u_apt.ref_bit VGND VGND VPWR VPWR net53 sky130_fd_sc_hd__dlygate4sd3_1
XFILLER_0_38_215 VGND VGND VPWR VPWR sky130_fd_sc_hd__decap_8
XFILLER_0_37_281 VGND VGND VPWR VPWR sky130_fd_sc_hd__decap_8
XFILLER_0_32_89 VGND VGND VPWR VPWR sky130_fd_sc_hd__decap_4
XFILLER_0_32_56 VGND VGND VPWR VPWR sky130_fd_sc_hd__fill_2
XFILLER_0_29_237 VPWR VGND VPWR VGND sky130_ef_sc_hd__decap_12
X_0644_ net17 _0162_ _0174_ _0172_ VGND VGND VPWR VPWR _0007_ sky130_fd_sc_hd__o211a_1
X_0713_ _0213_ _0232_ VGND VGND VPWR VPWR _0233_ sky130_fd_sc_hd__nor2_1
X_1058_ _0438_ _0489_ VGND VGND VPWR VPWR _0490_ sky130_fd_sc_hd__or2_1
X_1127_ _0542_ VGND VGND VPWR VPWR _0122_ sky130_fd_sc_hd__clkbuf_1
XFILLER_0_43_273 VGND VGND VPWR VPWR sky130_fd_sc_hd__decap_6
XFILLER_0_7_131 VPWR VGND VPWR VGND sky130_ef_sc_hd__decap_12
XFILLER_0_34_262 VGND VGND VPWR VPWR sky130_fd_sc_hd__decap_4
XTAP_129 VGND VPWR sky130_fd_sc_hd__tapvpwrvgnd_1
XTAP_118 VGND VPWR sky130_fd_sc_hd__tapvpwrvgnd_1
XTAP_107 VGND VPWR sky130_fd_sc_hd__tapvpwrvgnd_1
XPHY_1 VGND VGND VPWR VPWR sky130_fd_sc_hd__decap_3
XFILLER_0_25_251 VGND VGND VPWR VPWR sky130_fd_sc_hd__fill_1
XFILLER_0_7_55 VGND VGND VPWR VPWR sky130_fd_sc_hd__fill_1
X_0627_ u_apt.rst_n VGND VGND VPWR VPWR _0165_ sky130_fd_sc_hd__buf_2
XFILLER_0_30_3 VPWR VGND VPWR VGND sky130_ef_sc_hd__decap_12
Xu_ro_bank.g_ro\[2\].u_ro.g_stg\[6\].u_inv_u_cell u_ro_bank.g_ro\[2\].u_ro.n\[5\]
+ VGND VGND VPWR VPWR u_ro_bank.g_ro\[2\].u_ro.n\[6\] sky130_fd_sc_hd__inv_1
XFILLER_0_13_36 VPWR VGND VPWR VGND sky130_ef_sc_hd__decap_12
XFILLER_0_22_232 VGND VGND VPWR VPWR sky130_fd_sc_hd__fill_2
XFILLER_0_22_287 VGND VGND VPWR VPWR sky130_fd_sc_hd__decap_4
XFILLER_0_38_99 VGND VGND VPWR VPWR sky130_fd_sc_hd__fill_1
XFILLER_0_13_243 VGND VGND VPWR VPWR sky130_fd_sc_hd__decap_4
XFILLER_0_0_181 VPWR VGND VPWR VGND sky130_ef_sc_hd__decap_12
X_0961_ u_apt.cnt\[15\] u_apt.cnt\[14\] _0416_ _0417_ _0354_ VGND VGND VPWR VPWR _0418_
+ sky130_fd_sc_hd__o41a_1
XFILLER_0_6_207 VGND VGND VPWR VPWR sky130_fd_sc_hd__fill_1
X_0892_ u_apt.cnt\[2\] _0351_ _0354_ _0362_ VGND VGND VPWR VPWR _0363_ sky130_fd_sc_hd__a22o_1
XFILLER_0_40_23 VGND VGND VPWR VPWR sky130_fd_sc_hd__decap_4
XFILLER_0_4_78 VGND VGND VPWR VPWR sky130_fd_sc_hd__decap_6
XFILLER_0_5_273 VGND VGND VPWR VPWR sky130_fd_sc_hd__decap_6
XTAP_290 VGND VPWR sky130_fd_sc_hd__tapvpwrvgnd_1
XFILLER_0_36_121 VGND VGND VPWR VPWR sky130_fd_sc_hd__fill_1
XFILLER_0_10_26 VGND VGND VPWR VPWR sky130_fd_sc_hd__fill_2
X_1160_ div\[16\] _0559_ div\[17\] VGND VGND VPWR VPWR _0566_ sky130_fd_sc_hd__a21o_1
X_1091_ _0514_ _0457_ VGND VGND VPWR VPWR _0516_ sky130_fd_sc_hd__nor2_1
X_0944_ u_apt.cnt\[14\] u_apt.cnt\[13\] _0399_ _0374_ VGND VGND VPWR VPWR _0403_ sky130_fd_sc_hd__a31o_1
XFILLER_0_42_168 VGND VGND VPWR VPWR sky130_fd_sc_hd__fill_1
XFILLER_0_2_265 VPWR VGND VPWR VGND sky130_ef_sc_hd__decap_12
X_0875_ _0231_ _0348_ VGND VGND VPWR VPWR _0349_ sky130_fd_sc_hd__nor2_1
X_1358_ clknet_4_7_0_clk _0140_ VGND VGND VPWR VPWR div\[25\] sky130_fd_sc_hd__dfxtp_1
X_1289_ clknet_4_13_0_clk _0071_ VGND VGND VPWR VPWR u_apt.cnt\[6\] sky130_fd_sc_hd__dfxtp_1
Xu_ro_bank.g_ro\[1\].u_ro.g_stg\[2\].u_inv_u_cell u_ro_bank.g_ro\[1\].u_ro.n\[1\]
+ VGND VGND VPWR VPWR u_ro_bank.g_ro\[1\].u_ro.n\[2\] sky130_fd_sc_hd__inv_1
XFILLER_0_33_113 VGND VGND VPWR VPWR sky130_fd_sc_hd__fill_1
XFILLER_0_18_132 VGND VGND VPWR VPWR sky130_fd_sc_hd__decap_8
X_0660_ u_vn.o VGND VGND VPWR VPWR _0188_ sky130_fd_sc_hd__inv_2
X_1212_ div\[31\] div\[30\] _0593_ _0598_ VGND VGND VPWR VPWR _0604_ sky130_fd_sc_hd__nand4_1
X_1143_ net78 _0551_ _0521_ VGND VGND VPWR VPWR _0554_ sky130_fd_sc_hd__a21boi_1
XFILLER_0_1_57 VPWR VGND VPWR VGND sky130_ef_sc_hd__decap_12
X_1074_ u_uart.clk_cnt\[11\] _0427_ _0498_ _0502_ VGND VGND VPWR VPWR _0503_ sky130_fd_sc_hd__o31a_1
XFILLER_0_47_249 VPWR VGND VPWR VGND sky130_ef_sc_hd__decap_12
X_0927_ u_apt.cnt\[9\] _0388_ _0374_ VGND VGND VPWR VPWR _0391_ sky130_fd_sc_hd__a21oi_1
X_0789_ _0286_ VGND VGND VPWR VPWR _0040_ sky130_fd_sc_hd__clkbuf_1
XFILLER_0_30_149 VPWR VGND VPWR VGND sky130_ef_sc_hd__decap_12
X_0858_ u_apt.idx\[12\] _0332_ VGND VGND VPWR VPWR _0336_ sky130_fd_sc_hd__or2_1
XFILLER_0_30_105 VPWR VGND VPWR VGND sky130_ef_sc_hd__decap_12
Xhold59 u_apt.cnt\[8\] VGND VGND VPWR VPWR net65 sky130_fd_sc_hd__dlygate4sd3_1
Xhold48 div\[4\] VGND VGND VPWR VPWR net54 sky130_fd_sc_hd__dlygate4sd3_1
Xhold15 u_uart.shreg\[3\] VGND VGND VPWR VPWR net21 sky130_fd_sc_hd__dlygate4sd3_1
Xhold37 u_uart.shreg\[0\] VGND VGND VPWR VPWR net43 sky130_fd_sc_hd__dlygate4sd3_1
Xhold26 u_uart.tx_data\[3\] VGND VGND VPWR VPWR net32 sky130_fd_sc_hd__dlygate4sd3_1
XFILLER_0_38_205 VGND VGND VPWR VPWR sky130_fd_sc_hd__fill_1
XFILLER_0_29_249 VPWR VGND VPWR VGND sky130_ef_sc_hd__decap_12
XFILLER_0_12_116 VGND VGND VPWR VPWR sky130_fd_sc_hd__fill_1
X_0643_ u_vn.o _0163_ VGND VGND VPWR VPWR _0174_ sky130_fd_sc_hd__or2_1
X_0712_ _0214_ _0231_ VGND VGND VPWR VPWR _0232_ sky130_fd_sc_hd__or2_1
X_1126_ _0524_ _0540_ _0541_ VGND VGND VPWR VPWR _0542_ sky130_fd_sc_hd__and3_1
X_1057_ _0473_ _0488_ VGND VGND VPWR VPWR _0489_ sky130_fd_sc_hd__nor2_1
XFILLER_0_7_121 VGND VGND VPWR VPWR sky130_fd_sc_hd__fill_2
XFILLER_0_7_110 VGND VGND VPWR VPWR sky130_fd_sc_hd__fill_2
XFILLER_0_7_165 VGND VGND VPWR VPWR sky130_fd_sc_hd__decap_3
XFILLER_0_7_143 VGND VGND VPWR VPWR sky130_fd_sc_hd__fill_1
XTAP_119 VGND VPWR sky130_fd_sc_hd__tapvpwrvgnd_1
XTAP_108 VGND VPWR sky130_fd_sc_hd__tapvpwrvgnd_1
XPHY_2 VGND VGND VPWR VPWR sky130_fd_sc_hd__decap_3
Xclkbuf_0_clk clk VGND VGND VPWR VPWR clknet_0_clk sky130_fd_sc_hd__clkbuf_16
XFILLER_0_4_179 VGND VGND VPWR VPWR sky130_fd_sc_hd__fill_1
X_0626_ byte_reg\[0\] _0163_ VGND VGND VPWR VPWR _0164_ sky130_fd_sc_hd__or2_1
XFILLER_0_23_3 VPWR VGND VPWR VGND sky130_ef_sc_hd__decap_12
X_1109_ _0219_ _0220_ VGND VGND VPWR VPWR _0529_ sky130_fd_sc_hd__nand2_1
XFILLER_0_31_255 VGND VGND VPWR VPWR sky130_fd_sc_hd__decap_3
XFILLER_0_13_15 VPWR VGND VPWR VGND sky130_ef_sc_hd__decap_12
XFILLER_0_13_48 VGND VGND VPWR VPWR sky130_fd_sc_hd__decap_4
XFILLER_0_1_105 VGND VGND VPWR VPWR sky130_fd_sc_hd__decap_6
XFILLER_0_38_67 VGND VGND VPWR VPWR sky130_fd_sc_hd__fill_1
XFILLER_0_13_200 VGND VGND VPWR VPWR sky130_fd_sc_hd__fill_2
X_0609_ u_ro_bank.g_ro\[1\].u_ro.n\[4\] u_ro_bank.g_ro\[0\].u_ro.n\[2\] VGND VGND
+ VPWR VPWR _0148_ sky130_fd_sc_hd__xnor2_1
XFILLER_0_0_193 VGND VGND VPWR VPWR sky130_fd_sc_hd__decap_3
XFILLER_0_48_141 VPWR VGND VPWR VGND sky130_ef_sc_hd__decap_12
X_0960_ u_apt.cnt\[13\] u_apt.cnt\[12\] u_apt.cnt\[11\] u_apt.cnt\[10\] VGND VGND
+ VPWR VPWR _0417_ sky130_fd_sc_hd__or4_1
X_0891_ u_apt.cnt\[2\] _0357_ VGND VGND VPWR VPWR _0362_ sky130_fd_sc_hd__xnor2_1
XFILLER_0_40_68 VPWR VGND VPWR VGND sky130_ef_sc_hd__decap_12
XFILLER_0_10_214 VGND VGND VPWR VPWR sky130_fd_sc_hd__decap_8
XFILLER_0_10_258 VGND VGND VPWR VPWR sky130_fd_sc_hd__decap_4
XFILLER_0_45_166 VGND VGND VPWR VPWR sky130_fd_sc_hd__fill_2
XTAP_291 VGND VPWR sky130_fd_sc_hd__tapvpwrvgnd_1
XTAP_280 VGND VPWR sky130_fd_sc_hd__tapvpwrvgnd_1
XFILLER_0_36_144 VPWR VGND VPWR VGND sky130_ef_sc_hd__decap_12
Xu_ro_bank.g_ro\[7\].u_ro.g_stg\[3\].u_inv_u_cell u_ro_bank.g_ro\[7\].u_ro.n\[2\]
+ VGND VGND VPWR VPWR u_ro_bank.g_ro\[7\].u_ro.n\[3\] sky130_fd_sc_hd__inv_1
XFILLER_0_19_69 VPWR VGND VPWR VGND sky130_ef_sc_hd__decap_12
X_1090_ u_uart.clk_cnt\[14\] u_uart.clk_cnt\[13\] _0504_ _0427_ VGND VGND VPWR VPWR
+ _0515_ sky130_fd_sc_hd__a31o_1
X_0943_ net100 _0399_ _0402_ _0372_ VGND VGND VPWR VPWR _0078_ sky130_fd_sc_hd__o211a_1
X_0874_ _0328_ _0345_ _0346_ _0347_ VGND VGND VPWR VPWR _0348_ sky130_fd_sc_hd__or4_2
XFILLER_0_2_277 VPWR VGND VPWR VGND sky130_ef_sc_hd__decap_12
X_1357_ clknet_4_7_0_clk _0139_ VGND VGND VPWR VPWR div\[24\] sky130_fd_sc_hd__dfxtp_1
X_1288_ clknet_4_13_0_clk _0070_ VGND VGND VPWR VPWR u_apt.cnt\[5\] sky130_fd_sc_hd__dfxtp_1
XFILLER_0_18_188 VGND VGND VPWR VPWR sky130_fd_sc_hd__decap_8
XFILLER_0_21_15 VPWR VGND VPWR VGND sky130_ef_sc_hd__decap_12
X_1211_ div\[30\] _0593_ _0598_ div\[31\] VGND VGND VPWR VPWR _0603_ sky130_fd_sc_hd__a31o_1
X_1142_ _0553_ VGND VGND VPWR VPWR _0126_ sky130_fd_sc_hd__clkbuf_1
XFILLER_0_1_69 VPWR VGND VPWR VGND sky130_ef_sc_hd__decap_12
X_1073_ net104 _0499_ VGND VGND VPWR VPWR _0502_ sky130_fd_sc_hd__nand2_1
X_0926_ u_apt.cnt\[9\] _0356_ VGND VGND VPWR VPWR _0390_ sky130_fd_sc_hd__and2_1
XFILLER_0_11_81 VPWR VGND VPWR VGND sky130_ef_sc_hd__decap_12
XFILLER_0_15_136 VGND VGND VPWR VPWR sky130_fd_sc_hd__decap_8
XFILLER_0_15_169 VGND VGND VPWR VPWR sky130_fd_sc_hd__decap_6
X_0857_ u_apt.idx\[12\] u_apt.idx\[11\] u_apt.idx\[10\] _0326_ VGND VGND VPWR VPWR
+ _0335_ sky130_fd_sc_hd__and4_1
XFILLER_0_30_117 VPWR VGND VPWR VGND sky130_ef_sc_hd__decap_12
X_0788_ _0201_ _0283_ _0285_ VGND VGND VPWR VPWR _0286_ sky130_fd_sc_hd__and3_1
Xhold16 u_uart.shreg\[1\] VGND VGND VPWR VPWR net22 sky130_fd_sc_hd__dlygate4sd3_1
Xhold27 _0003_ VGND VGND VPWR VPWR net33 sky130_fd_sc_hd__dlygate4sd3_1
Xhold38 u_uart.tx_data\[0\] VGND VGND VPWR VPWR net44 sky130_fd_sc_hd__dlygate4sd3_1
XFILLER_0_23_191 VPWR VGND VPWR VGND sky130_ef_sc_hd__decap_12
XFILLER_0_30_139 VGND VGND VPWR VPWR sky130_fd_sc_hd__fill_1
Xhold49 u_rct.last VGND VGND VPWR VPWR net55 sky130_fd_sc_hd__dlygate4sd3_1
XFILLER_0_21_106 VGND VGND VPWR VPWR sky130_fd_sc_hd__fill_1
XFILLER_0_21_139 VPWR VGND VPWR VGND sky130_ef_sc_hd__decap_12
XFILLER_0_16_15 VGND VGND VPWR VPWR sky130_fd_sc_hd__decap_8
XFILLER_0_16_26 VGND VGND VPWR VPWR sky130_fd_sc_hd__fill_2
XFILLER_0_32_47 VGND VGND VPWR VPWR sky130_fd_sc_hd__fill_1
XFILLER_0_32_14 VGND VGND VPWR VPWR sky130_fd_sc_hd__decap_8
XFILLER_0_37_261 VGND VGND VPWR VPWR sky130_fd_sc_hd__decap_6
X_0711_ _0230_ VGND VGND VPWR VPWR _0231_ sky130_fd_sc_hd__clkbuf_4
Xu_ro_bank.g_ro\[3\].u_ro.g_stg\[6\].u_inv_u_cell u_ro_bank.g_ro\[3\].u_ro.n\[5\]
+ VGND VGND VPWR VPWR u_ro_bank.g_ro\[3\].u_ro.n\[6\] sky130_fd_sc_hd__inv_1
XFILLER_0_12_128 VGND VGND VPWR VPWR sky130_fd_sc_hd__decap_6
X_0642_ net30 _0162_ _0173_ _0172_ VGND VGND VPWR VPWR _0006_ sky130_fd_sc_hd__o211a_1
X_1125_ div\[7\] _0537_ VGND VGND VPWR VPWR _0541_ sky130_fd_sc_hd__or2_1
X_1056_ u_uart.clk_cnt\[8\] u_uart.clk_cnt\[7\] _0484_ VGND VGND VPWR VPWR _0488_
+ sky130_fd_sc_hd__and3_1
XFILLER_0_28_261 VGND VGND VPWR VPWR sky130_fd_sc_hd__decap_3
X_0909_ u_apt.cnt\[4\] _0365_ u_apt.cnt\[5\] VGND VGND VPWR VPWR _0377_ sky130_fd_sc_hd__a21o_1
XFILLER_0_7_177 VGND VGND VPWR VPWR sky130_fd_sc_hd__fill_1
XFILLER_0_22_91 VGND VGND VPWR VPWR sky130_fd_sc_hd__fill_2
XFILLER_0_9_9 VGND VGND VPWR VPWR sky130_fd_sc_hd__decap_6
XFILLER_0_34_253 VGND VGND VPWR VPWR sky130_fd_sc_hd__fill_2
Xu_ro_bank.g_ro\[0\].u_ro.u_nand_u_cell u_ro_bank.g_ro\[0\].u_ro.n\[2\] u_ro_bank.en
+ VGND VGND VPWR VPWR u_ro_bank.g_ro\[0\].u_ro.n\[0\] sky130_fd_sc_hd__nand2_1
XTAP_109 VGND VPWR sky130_fd_sc_hd__tapvpwrvgnd_1
XFILLER_0_43_57 VGND VGND VPWR VPWR sky130_fd_sc_hd__decap_8
XPHY_3 VGND VGND VPWR VPWR sky130_fd_sc_hd__decap_3
XFILLER_0_7_57 VGND VGND VPWR VPWR sky130_fd_sc_hd__decap_8
XFILLER_0_7_24 VPWR VGND VPWR VGND sky130_ef_sc_hd__decap_12
X_0625_ _0156_ _0158_ _0160_ VGND VGND VPWR VPWR _0163_ sky130_fd_sc_hd__or3b_2
XFILLER_0_25_220 VGND VGND VPWR VPWR sky130_fd_sc_hd__decap_4
X_1039_ _0201_ _0475_ _0476_ VGND VGND VPWR VPWR _0477_ sky130_fd_sc_hd__and3_1
XFILLER_0_16_3 VPWR VGND VPWR VGND sky130_ef_sc_hd__decap_12
X_1108_ _0528_ VGND VGND VPWR VPWR _0117_ sky130_fd_sc_hd__clkbuf_1
Xu_ro_bank.g_ro\[2\].u_ro.u_nand_u_cell u_ro_bank.g_ro\[2\].u_ro.n\[6\] u_ro_bank.en
+ VGND VGND VPWR VPWR u_ro_bank.g_ro\[2\].u_ro.n\[0\] sky130_fd_sc_hd__nand2_1
XFILLER_0_31_289 VGND VGND VPWR VPWR sky130_fd_sc_hd__fill_2
XFILLER_0_31_278 VGND VGND VPWR VPWR sky130_fd_sc_hd__fill_2
XFILLER_0_38_46 VGND VGND VPWR VPWR sky130_fd_sc_hd__fill_1
XFILLER_0_38_35 VGND VGND VPWR VPWR sky130_fd_sc_hd__decap_8
Xu_ro_bank.g_ro\[4\].u_ro.u_nand_u_cell u_ro_bank.g_ro\[4\].u_ro.n\[10\] u_ro_bank.en
+ VGND VGND VPWR VPWR u_ro_bank.g_ro\[4\].u_ro.n\[0\] sky130_fd_sc_hd__nand2_1
XFILLER_0_13_278 VGND VGND VPWR VPWR sky130_fd_sc_hd__fill_2
XFILLER_0_13_289 VGND VGND VPWR VPWR sky130_fd_sc_hd__fill_2
X_0608_ _0147_ VGND VGND VPWR VPWR net4 sky130_fd_sc_hd__buf_1
XFILLER_0_48_153 VPWR VGND VPWR VGND sky130_ef_sc_hd__decap_12
XFILLER_0_48_197 VPWR VGND VPWR VGND sky130_ef_sc_hd__decap_12
XFILLER_0_8_261 VGND VGND VPWR VPWR sky130_fd_sc_hd__decap_4
Xu_ro_bank.g_ro\[6\].u_ro.u_nand_u_cell u_ro_bank.g_ro\[6\].u_ro.n\[14\] u_ro_bank.en
+ VGND VGND VPWR VPWR u_ro_bank.g_ro\[6\].u_ro.n\[0\] sky130_fd_sc_hd__nand2_1
XFILLER_0_5_3 VGND VGND VPWR VPWR sky130_fd_sc_hd__decap_8
Xu_ro_bank.g_ro\[2\].u_ro.g_stg\[2\].u_inv_u_cell u_ro_bank.g_ro\[2\].u_ro.n\[1\]
+ VGND VGND VPWR VPWR u_ro_bank.g_ro\[2\].u_ro.n\[2\] sky130_fd_sc_hd__inv_1
XFILLER_0_24_15 VPWR VGND VPWR VGND sky130_ef_sc_hd__decap_12
XFILLER_0_24_37 VGND VGND VPWR VPWR sky130_fd_sc_hd__fill_1
X_0890_ _0361_ VGND VGND VPWR VPWR _0066_ sky130_fd_sc_hd__clkbuf_1
XFILLER_0_10_248 VGND VGND VPWR VPWR sky130_fd_sc_hd__decap_4
XFILLER_0_45_134 VPWR VGND VPWR VGND sky130_ef_sc_hd__decap_12
XFILLER_0_30_91 VGND VGND VPWR VPWR sky130_fd_sc_hd__fill_1
XTAP_292 VGND VPWR sky130_fd_sc_hd__tapvpwrvgnd_1
XTAP_281 VGND VPWR sky130_fd_sc_hd__tapvpwrvgnd_1
XTAP_270 VGND VPWR sky130_fd_sc_hd__tapvpwrvgnd_1
XFILLER_0_10_39 VGND VGND VPWR VPWR sky130_fd_sc_hd__fill_1
XFILLER_0_19_15 VPWR VGND VPWR VGND sky130_ef_sc_hd__decap_12
X_0942_ _0401_ _0374_ _0356_ u_apt.cnt\[13\] VGND VGND VPWR VPWR _0402_ sky130_fd_sc_hd__a2bb2o_1
X_0873_ u_apt.idx\[3\] u_apt.idx\[2\] u_apt.idx\[1\] u_apt.idx\[0\] VGND VGND VPWR
+ VPWR _0347_ sky130_fd_sc_hd__or4_1
XFILLER_0_27_167 VGND VGND VPWR VPWR sky130_fd_sc_hd__fill_1
XFILLER_0_2_289 VGND VGND VPWR VPWR sky130_fd_sc_hd__fill_2
X_1356_ clknet_4_5_0_clk _0138_ VGND VGND VPWR VPWR div\[23\] sky130_fd_sc_hd__dfxtp_1
X_1287_ clknet_4_13_0_clk _0069_ VGND VGND VPWR VPWR u_apt.cnt\[4\] sky130_fd_sc_hd__dfxtp_1
XFILLER_0_21_27 VPWR VGND VPWR VGND sky130_ef_sc_hd__decap_12
XFILLER_0_24_137 VGND VGND VPWR VPWR sky130_fd_sc_hd__decap_3
XFILLER_0_32_192 VGND VGND VPWR VPWR sky130_fd_sc_hd__decap_4
X_1210_ _0601_ _0599_ _0602_ _0521_ VGND VGND VPWR VPWR _0145_ sky130_fd_sc_hd__o211a_1
X_1141_ _0551_ _0524_ _0552_ VGND VGND VPWR VPWR _0553_ sky130_fd_sc_hd__and3b_1
XFILLER_0_1_15 VPWR VGND VPWR VGND sky130_ef_sc_hd__decap_12
X_1072_ _0236_ _0501_ VGND VGND VPWR VPWR _0108_ sky130_fd_sc_hd__nor2_1
X_0925_ _0386_ _0389_ _0236_ VGND VGND VPWR VPWR _0073_ sky130_fd_sc_hd__a21oi_1
X_0787_ _0284_ _0276_ _0278_ VGND VGND VPWR VPWR _0285_ sky130_fd_sc_hd__a21o_1
XFILLER_0_11_93 VGND VGND VPWR VPWR sky130_fd_sc_hd__decap_6
X_0856_ _0334_ VGND VGND VPWR VPWR _0059_ sky130_fd_sc_hd__clkbuf_1
XFILLER_0_30_129 VGND VGND VPWR VPWR sky130_fd_sc_hd__decap_6
XFILLER_0_46_3 VPWR VGND VPWR VGND sky130_ef_sc_hd__decap_12
Xhold39 _0000_ VGND VGND VPWR VPWR net45 sky130_fd_sc_hd__dlygate4sd3_1
Xhold17 u_uart.clk_cnt\[12\] VGND VGND VPWR VPWR net23 sky130_fd_sc_hd__dlygate4sd3_1
Xhold28 u_uart.tx_data\[4\] VGND VGND VPWR VPWR net34 sky130_fd_sc_hd__dlygate4sd3_1
X_1339_ clknet_4_4_0_clk _0121_ VGND VGND VPWR VPWR div\[6\] sky130_fd_sc_hd__dfxtp_1
XFILLER_0_46_251 VGND VGND VPWR VPWR sky130_fd_sc_hd__fill_1
X_0710_ _0218_ _0221_ _0226_ _0229_ VGND VGND VPWR VPWR _0230_ sky130_fd_sc_hd__or4_4
X_0641_ byte_reg\[6\] _0163_ VGND VGND VPWR VPWR _0173_ sky130_fd_sc_hd__or2_1
XFILLER_0_20_195 VGND VGND VPWR VPWR sky130_fd_sc_hd__fill_1
X_1055_ u_uart.clk_cnt\[7\] _0484_ _0487_ _0456_ VGND VGND VPWR VPWR _0105_ sky130_fd_sc_hd__o211a_1
X_1124_ div\[7\] _0537_ VGND VGND VPWR VPWR _0540_ sky130_fd_sc_hd__nand2_1
XFILLER_0_28_251 VGND VGND VPWR VPWR sky130_fd_sc_hd__fill_1
X_0908_ _0365_ _0375_ VGND VGND VPWR VPWR _0376_ sky130_fd_sc_hd__nand2_1
XFILLER_0_11_162 VGND VGND VPWR VPWR sky130_fd_sc_hd__fill_2
X_0839_ u_apt.idx\[6\] _0314_ _0316_ u_apt.idx\[7\] VGND VGND VPWR VPWR _0322_ sky130_fd_sc_hd__a31o_1
XFILLER_0_34_287 VGND VGND VPWR VPWR sky130_fd_sc_hd__decap_4
XPHY_4 VGND VGND VPWR VPWR sky130_fd_sc_hd__decap_3
XFILLER_0_7_36 VGND VGND VPWR VPWR sky130_fd_sc_hd__decap_6
XFILLER_0_4_159 VPWR VGND VPWR VGND sky130_ef_sc_hd__decap_12
X_0624_ _0161_ VGND VGND VPWR VPWR _0162_ sky130_fd_sc_hd__buf_2
X_1038_ u_uart.clk_cnt\[1\] u_uart.clk_cnt\[0\] u_uart.clk_cnt\[2\] VGND VGND VPWR
+ VPWR _0476_ sky130_fd_sc_hd__a21o_1
X_1107_ _0165_ _0220_ _0527_ VGND VGND VPWR VPWR _0528_ sky130_fd_sc_hd__and3_1
XFILLER_0_16_287 VGND VGND VPWR VPWR sky130_fd_sc_hd__decap_4
XFILLER_0_13_213 VGND VGND VPWR VPWR sky130_fd_sc_hd__decap_3
X_0607_ u_apt.fail u_rct.fail VGND VGND VPWR VPWR _0147_ sky130_fd_sc_hd__or2_1
XFILLER_0_48_165 VGND VGND VPWR VPWR sky130_fd_sc_hd__decap_3
XFILLER_0_8_251 VGND VGND VPWR VPWR sky130_fd_sc_hd__fill_1
XFILLER_0_24_27 VGND VGND VPWR VPWR sky130_fd_sc_hd__fill_1
XFILLER_0_45_146 VPWR VGND VPWR VGND sky130_ef_sc_hd__decap_12
XFILLER_0_5_221 VGND VGND VPWR VPWR sky130_fd_sc_hd__decap_3
XTAP_293 VGND VPWR sky130_fd_sc_hd__tapvpwrvgnd_1
XTAP_282 VGND VPWR sky130_fd_sc_hd__tapvpwrvgnd_1
XTAP_271 VGND VPWR sky130_fd_sc_hd__tapvpwrvgnd_1
XTAP_260 VGND VPWR sky130_fd_sc_hd__tapvpwrvgnd_1
XFILLER_0_10_29 VGND VGND VPWR VPWR sky130_fd_sc_hd__decap_3
XFILLER_0_19_27 VPWR VGND VPWR VGND sky130_ef_sc_hd__decap_12
X_0941_ u_apt.cnt\[13\] _0399_ VGND VGND VPWR VPWR _0401_ sky130_fd_sc_hd__and2_1
XFILLER_0_27_113 VGND VGND VPWR VPWR sky130_fd_sc_hd__decap_6
X_0872_ u_apt.idx\[11\] u_apt.idx\[10\] u_apt.idx\[9\] u_apt.idx\[8\] VGND VGND VPWR
+ VPWR _0346_ sky130_fd_sc_hd__or4_1
X_1355_ clknet_4_5_0_clk _0137_ VGND VGND VPWR VPWR div\[22\] sky130_fd_sc_hd__dfxtp_1
X_1286_ clknet_4_15_0_clk _0068_ VGND VGND VPWR VPWR u_apt.cnt\[3\] sky130_fd_sc_hd__dfxtp_1
Xu_ro_bank.g_ro\[4\].u_ro.g_stg\[6\].u_inv_u_cell u_ro_bank.g_ro\[4\].u_ro.n\[5\]
+ VGND VGND VPWR VPWR u_ro_bank.g_ro\[4\].u_ro.n\[6\] sky130_fd_sc_hd__inv_1
XFILLER_0_21_39 VPWR VGND VPWR VGND sky130_ef_sc_hd__decap_12
X_1140_ div\[11\] _0548_ VGND VGND VPWR VPWR _0552_ sky130_fd_sc_hd__or2_1
XFILLER_0_1_27 VPWR VGND VPWR VGND sky130_ef_sc_hd__decap_12
X_1071_ net50 _0499_ _0500_ VGND VGND VPWR VPWR _0501_ sky130_fd_sc_hd__a21oi_1
X_0924_ _0374_ _0387_ _0388_ VGND VGND VPWR VPWR _0389_ sky130_fd_sc_hd__or3_1
X_0786_ _0269_ VGND VGND VPWR VPWR _0284_ sky130_fd_sc_hd__inv_2
X_0855_ _0332_ _0333_ _0251_ VGND VGND VPWR VPWR _0334_ sky130_fd_sc_hd__and3b_1
X_1338_ clknet_4_6_0_clk _0120_ VGND VGND VPWR VPWR div\[5\] sky130_fd_sc_hd__dfxtp_1
Xhold18 u_uart.tx_data\[5\] VGND VGND VPWR VPWR net24 sky130_fd_sc_hd__dlygate4sd3_1
Xhold29 _0004_ VGND VGND VPWR VPWR net35 sky130_fd_sc_hd__dlygate4sd3_1
XFILLER_0_36_80 VGND VGND VPWR VPWR sky130_fd_sc_hd__decap_4
X_1269_ clknet_4_6_0_clk net19 VGND VGND VPWR VPWR u_apt.idx\[3\] sky130_fd_sc_hd__dfxtp_1
XFILLER_0_32_27 VGND VGND VPWR VPWR sky130_fd_sc_hd__fill_1
X_0640_ net24 _0162_ _0171_ _0172_ VGND VGND VPWR VPWR _0005_ sky130_fd_sc_hd__o211a_1
XFILLER_0_20_141 VPWR VGND VPWR VGND sky130_ef_sc_hd__decap_12
X_1054_ u_uart.clk_cnt\[7\] _0457_ _0486_ _0425_ VGND VGND VPWR VPWR _0487_ sky130_fd_sc_hd__a22o_1
X_1123_ _0539_ VGND VGND VPWR VPWR _0121_ sky130_fd_sc_hd__clkbuf_1
X_0907_ u_apt.cnt\[5\] u_apt.cnt\[4\] VGND VGND VPWR VPWR _0375_ sky130_fd_sc_hd__and2_1
XFILLER_0_43_222 VGND VGND VPWR VPWR sky130_fd_sc_hd__fill_2
XFILLER_0_7_113 VGND VGND VPWR VPWR sky130_fd_sc_hd__decap_8
XFILLER_0_28_230 VPWR VGND VPWR VGND sky130_ef_sc_hd__decap_12
X_0769_ u_rct.cnt\[2\] u_rct.cnt\[1\] u_rct.cnt\[0\] VGND VGND VPWR VPWR _0269_ sky130_fd_sc_hd__and3_1
X_0838_ u_apt.idx\[7\] u_apt.idx\[6\] _0314_ _0316_ VGND VGND VPWR VPWR _0321_ sky130_fd_sc_hd__and4_1
XFILLER_0_34_266 VGND VGND VPWR VPWR sky130_fd_sc_hd__fill_1
XFILLER_0_43_15 VGND VGND VPWR VPWR sky130_fd_sc_hd__fill_1
XPHY_5 VGND VGND VPWR VPWR sky130_fd_sc_hd__decap_3
XFILLER_0_25_233 VGND VGND VPWR VPWR sky130_fd_sc_hd__fill_2
XFILLER_0_40_247 VGND VGND VPWR VPWR sky130_fd_sc_hd__decap_4
X_0623_ _0159_ _0160_ VGND VGND VPWR VPWR _0161_ sky130_fd_sc_hd__and2b_1
Xu_ro_bank.g_ro\[3\].u_ro.g_stg\[2\].u_inv_u_cell u_ro_bank.g_ro\[3\].u_ro.n\[1\]
+ VGND VGND VPWR VPWR u_ro_bank.g_ro\[3\].u_ro.n\[2\] sky130_fd_sc_hd__inv_1
X_1106_ div\[1\] div\[0\] div\[2\] VGND VGND VPWR VPWR _0527_ sky130_fd_sc_hd__a21o_1
X_1037_ _0473_ _0474_ u_uart.clk_cnt\[2\] _0457_ VGND VGND VPWR VPWR _0475_ sky130_fd_sc_hd__a2bb2o_1
XFILLER_0_31_236 VGND VGND VPWR VPWR sky130_fd_sc_hd__fill_1
XFILLER_0_31_225 VGND VGND VPWR VPWR sky130_fd_sc_hd__decap_3
XFILLER_0_22_269 VGND VGND VPWR VPWR sky130_fd_sc_hd__fill_2
XFILLER_0_13_247 VGND VGND VPWR VPWR sky130_fd_sc_hd__fill_1
XFILLER_0_0_141 VGND VGND VPWR VPWR sky130_fd_sc_hd__decap_4
XFILLER_0_0_152 VPWR VGND VPWR VGND sky130_ef_sc_hd__decap_12
XFILLER_0_21_3 VPWR VGND VPWR VGND sky130_ef_sc_hd__decap_12
XFILLER_0_28_81 VGND VGND VPWR VPWR sky130_fd_sc_hd__decap_3
XFILLER_0_40_27 VGND VGND VPWR VPWR sky130_fd_sc_hd__fill_1
XFILLER_0_4_38 VGND VGND VPWR VPWR sky130_fd_sc_hd__fill_1
XFILLER_0_45_158 VGND VGND VPWR VPWR sky130_fd_sc_hd__decap_8
XTAP_294 VGND VPWR sky130_fd_sc_hd__tapvpwrvgnd_1
XTAP_283 VGND VPWR sky130_fd_sc_hd__tapvpwrvgnd_1
XTAP_272 VGND VPWR sky130_fd_sc_hd__tapvpwrvgnd_1
XTAP_261 VGND VPWR sky130_fd_sc_hd__tapvpwrvgnd_1
XTAP_250 VGND VPWR sky130_fd_sc_hd__tapvpwrvgnd_1
XFILLER_0_36_169 VGND VGND VPWR VPWR sky130_fd_sc_hd__decap_3
XFILLER_0_36_125 VPWR VGND VPWR VGND sky130_ef_sc_hd__decap_12
XFILLER_0_19_39 VGND VGND VPWR VPWR sky130_fd_sc_hd__decap_6
X_0940_ _0398_ _0396_ _0400_ _0239_ VGND VGND VPWR VPWR _0077_ sky130_fd_sc_hd__a211oi_1
XFILLER_0_27_158 VGND VGND VPWR VPWR sky130_fd_sc_hd__fill_1
XFILLER_0_27_169 VGND VGND VPWR VPWR sky130_fd_sc_hd__fill_2
X_0871_ u_apt.idx\[7\] u_apt.idx\[6\] u_apt.idx\[5\] u_apt.idx\[4\] VGND VGND VPWR
+ VPWR _0345_ sky130_fd_sc_hd__or4_1
X_1354_ clknet_4_5_0_clk _0136_ VGND VGND VPWR VPWR div\[21\] sky130_fd_sc_hd__dfxtp_1
X_1285_ clknet_4_15_0_clk _0067_ VGND VGND VPWR VPWR u_apt.cnt\[2\] sky130_fd_sc_hd__dfxtp_1
XFILLER_0_33_139 VPWR VGND VPWR VGND sky130_ef_sc_hd__decap_12
XFILLER_0_5_81 VGND VGND VPWR VPWR sky130_fd_sc_hd__decap_4
XFILLER_0_32_172 VPWR VGND VPWR VGND sky130_ef_sc_hd__decap_12
XFILLER_0_46_15 VPWR VGND VPWR VGND sky130_ef_sc_hd__decap_12
XFILLER_0_1_39 VGND VGND VPWR VPWR sky130_fd_sc_hd__decap_8
X_1070_ _0437_ _0496_ _0498_ VGND VGND VPWR VPWR _0500_ sky130_fd_sc_hd__and3_1
X_0923_ u_apt.cnt\[8\] _0382_ VGND VGND VPWR VPWR _0388_ sky130_fd_sc_hd__and2_1
X_0854_ u_apt.idx\[10\] _0326_ u_apt.idx\[11\] VGND VGND VPWR VPWR _0333_ sky130_fd_sc_hd__a21o_1
X_0785_ u_rct.cnt\[1\] u_rct.cnt\[0\] _0277_ u_rct.cnt\[2\] VGND VGND VPWR VPWR _0283_
+ sky130_fd_sc_hd__a31o_1
XFILLER_0_23_183 VGND VGND VPWR VPWR sky130_fd_sc_hd__fill_1
X_1268_ clknet_4_6_0_clk _0050_ VGND VGND VPWR VPWR u_apt.idx\[2\] sky130_fd_sc_hd__dfxtp_1
X_1337_ clknet_4_4_0_clk _0119_ VGND VGND VPWR VPWR div\[4\] sky130_fd_sc_hd__dfxtp_1
Xhold19 _0005_ VGND VGND VPWR VPWR net25 sky130_fd_sc_hd__dlygate4sd3_1
X_1199_ _0593_ _0535_ _0594_ VGND VGND VPWR VPWR _0595_ sky130_fd_sc_hd__and3b_1
XFILLER_0_46_253 VPWR VGND VPWR VGND sky130_ef_sc_hd__decap_12
XFILLER_0_16_29 VPWR VGND VPWR VGND sky130_ef_sc_hd__decap_12
XFILLER_0_37_275 VGND VGND VPWR VPWR sky130_fd_sc_hd__decap_4
XFILLER_0_20_153 VPWR VGND VPWR VGND sky130_ef_sc_hd__decap_12
X_1122_ _0537_ _0524_ _0538_ VGND VGND VPWR VPWR _0539_ sky130_fd_sc_hd__and3b_1
X_1053_ u_uart.clk_cnt\[7\] _0484_ VGND VGND VPWR VPWR _0486_ sky130_fd_sc_hd__nand2_1
XFILLER_0_28_242 VGND VGND VPWR VPWR sky130_fd_sc_hd__fill_2
XFILLER_0_43_289 VGND VGND VPWR VPWR sky130_fd_sc_hd__fill_2
X_0906_ _0373_ VGND VGND VPWR VPWR _0374_ sky130_fd_sc_hd__buf_2
XFILLER_0_7_169 VGND VGND VPWR VPWR sky130_fd_sc_hd__fill_1
XFILLER_0_22_83 VGND VGND VPWR VPWR sky130_fd_sc_hd__fill_1
XFILLER_0_28_253 VGND VGND VPWR VPWR sky130_fd_sc_hd__decap_3
X_0837_ net88 _0317_ _0320_ VGND VGND VPWR VPWR _0054_ sky130_fd_sc_hd__o21a_1
X_0768_ _0268_ VGND VGND VPWR VPWR _0037_ sky130_fd_sc_hd__clkbuf_1
X_0699_ div\[3\] VGND VGND VPWR VPWR _0219_ sky130_fd_sc_hd__inv_2
XFILLER_0_47_80 VGND VGND VPWR VPWR sky130_fd_sc_hd__decap_3
XFILLER_0_2_71 VPWR VGND VPWR VGND sky130_ef_sc_hd__decap_12
XFILLER_0_34_223 VGND VGND VPWR VPWR sky130_fd_sc_hd__fill_2
XFILLER_0_19_253 VGND VGND VPWR VPWR sky130_fd_sc_hd__decap_3
XPHY_6 VGND VGND VPWR VPWR sky130_fd_sc_hd__decap_3
XFILLER_0_7_49 VGND VGND VPWR VPWR sky130_fd_sc_hd__decap_6
X_0622_ net63 net92 VGND VGND VPWR VPWR _0160_ sky130_fd_sc_hd__nand2_1
XFILLER_0_17_72 VGND VGND VPWR VPWR sky130_fd_sc_hd__fill_2
X_1105_ _0526_ VGND VGND VPWR VPWR _0116_ sky130_fd_sc_hd__clkbuf_1
X_1036_ u_uart.clk_cnt\[2\] u_uart.clk_cnt\[1\] u_uart.clk_cnt\[0\] VGND VGND VPWR
+ VPWR _0474_ sky130_fd_sc_hd__and3_1
X_1254__6 VGND VGND VPWR VPWR net6 _1254__6/LO sky130_fd_sc_hd__conb_1
XFILLER_0_38_27 VGND VGND VPWR VPWR sky130_fd_sc_hd__fill_1
XFILLER_0_0_164 VGND VGND VPWR VPWR sky130_fd_sc_hd__decap_4
XFILLER_0_0_197 VPWR VGND VPWR VGND sky130_ef_sc_hd__decap_12
XFILLER_0_21_281 VGND VGND VPWR VPWR sky130_fd_sc_hd__fill_2
X_1019_ u_uart.bit_cnt\[1\] u_uart.bit_cnt\[0\] VGND VGND VPWR VPWR _0462_ sky130_fd_sc_hd__nand2_1
XFILLER_0_14_3 VPWR VGND VPWR VGND sky130_ef_sc_hd__decap_12
Xu_ro_bank.g_ro\[5\].u_ro.g_stg\[6\].u_inv_u_cell u_ro_bank.g_ro\[5\].u_ro.n\[5\]
+ VGND VGND VPWR VPWR u_ro_bank.g_ro\[5\].u_ro.n\[6\] sky130_fd_sc_hd__inv_1
XFILLER_0_24_29 VGND VGND VPWR VPWR sky130_fd_sc_hd__decap_8
XFILLER_0_5_289 VGND VGND VPWR VPWR sky130_fd_sc_hd__fill_2
XTAP_295 VGND VPWR sky130_fd_sc_hd__tapvpwrvgnd_1
XTAP_284 VGND VPWR sky130_fd_sc_hd__tapvpwrvgnd_1
XTAP_273 VGND VPWR sky130_fd_sc_hd__tapvpwrvgnd_1
XTAP_262 VGND VPWR sky130_fd_sc_hd__tapvpwrvgnd_1
XTAP_240 VGND VPWR sky130_fd_sc_hd__tapvpwrvgnd_1
XTAP_251 VGND VPWR sky130_fd_sc_hd__tapvpwrvgnd_1
XFILLER_0_36_137 VGND VGND VPWR VPWR sky130_fd_sc_hd__decap_3
XFILLER_0_3_3 VGND VGND VPWR VPWR sky130_fd_sc_hd__decap_3
X_0870_ net9 _0341_ _0344_ VGND VGND VPWR VPWR _0063_ sky130_fd_sc_hd__a21oi_1
X_1353_ clknet_4_5_0_clk net83 VGND VGND VPWR VPWR div\[20\] sky130_fd_sc_hd__dfxtp_1
X_1284_ clknet_4_15_0_clk _0066_ VGND VGND VPWR VPWR u_apt.cnt\[1\] sky130_fd_sc_hd__dfxtp_1
X_0999_ u_uart.tx_data\[3\] u_uart.shreg\[4\] _0424_ VGND VGND VPWR VPWR _0448_ sky130_fd_sc_hd__mux2_1
XFILLER_0_26_170 VPWR VGND VPWR VGND sky130_ef_sc_hd__decap_12
XFILLER_0_41_195 VGND VGND VPWR VPWR sky130_fd_sc_hd__fill_2
XFILLER_0_41_162 VGND VGND VPWR VPWR sky130_fd_sc_hd__fill_2
XFILLER_0_1_281 VGND VGND VPWR VPWR sky130_fd_sc_hd__decap_8
XFILLER_0_32_184 VGND VGND VPWR VPWR sky130_fd_sc_hd__fill_2
XFILLER_0_24_129 VGND VGND VPWR VPWR sky130_fd_sc_hd__decap_8
XFILLER_0_46_27 VGND VGND VPWR VPWR sky130_fd_sc_hd__fill_1
X_0922_ u_apt.cnt\[8\] _0382_ VGND VGND VPWR VPWR _0387_ sky130_fd_sc_hd__nor2_1
X_0853_ u_apt.idx\[11\] u_apt.idx\[10\] _0326_ VGND VGND VPWR VPWR _0332_ sky130_fd_sc_hd__and3_1
X_0784_ net87 _0277_ _0282_ _0172_ VGND VGND VPWR VPWR _0039_ sky130_fd_sc_hd__o211a_1
Xinput1 rst_n VGND VGND VPWR VPWR net1 sky130_fd_sc_hd__buf_1
X_1198_ div\[27\] _0589_ VGND VGND VPWR VPWR _0594_ sky130_fd_sc_hd__or2_1
X_1267_ clknet_4_6_0_clk _0049_ VGND VGND VPWR VPWR u_apt.idx\[1\] sky130_fd_sc_hd__dfxtp_1
X_1336_ clknet_4_6_0_clk _0118_ VGND VGND VPWR VPWR div\[3\] sky130_fd_sc_hd__dfxtp_1
XFILLER_0_46_265 VPWR VGND VPWR VGND sky130_ef_sc_hd__decap_12
Xu_ro_bank.g_ro\[5\].u_ro.g_stg\[12\].u_inv_u_cell u_ro_bank.g_ro\[5\].u_ro.n\[11\]
+ VGND VGND VPWR VPWR u_ro_bank.g_ro\[5\].u_ro.n\[12\] sky130_fd_sc_hd__inv_1
Xu_ro_bank.g_ro\[4\].u_ro.g_stg\[2\].u_inv_u_cell u_ro_bank.g_ro\[4\].u_ro.n\[1\]
+ VGND VGND VPWR VPWR u_ro_bank.g_ro\[4\].u_ro.n\[2\] sky130_fd_sc_hd__inv_1
XFILLER_0_32_29 VGND VGND VPWR VPWR sky130_fd_sc_hd__fill_2
XFILLER_0_20_165 VPWR VGND VPWR VGND sky130_ef_sc_hd__decap_12
X_1121_ div\[6\] _0533_ VGND VGND VPWR VPWR _0538_ sky130_fd_sc_hd__or2_1
X_1052_ net68 _0482_ _0485_ _0456_ VGND VGND VPWR VPWR _0104_ sky130_fd_sc_hd__o211a_1
XFILLER_0_28_276 VPWR VGND VPWR VGND sky130_ef_sc_hd__decap_12
XFILLER_0_43_279 VGND VGND VPWR VPWR sky130_fd_sc_hd__fill_1
X_0905_ _0230_ _0353_ VGND VGND VPWR VPWR _0373_ sky130_fd_sc_hd__or2_1
X_0767_ net66 _0201_ VGND VGND VPWR VPWR _0268_ sky130_fd_sc_hd__and2_1
XFILLER_0_11_121 VGND VGND VPWR VPWR sky130_fd_sc_hd__decap_8
X_0836_ u_apt.idx\[6\] _0317_ _0239_ VGND VGND VPWR VPWR _0320_ sky130_fd_sc_hd__a21oi_1
XFILLER_0_44_3 VPWR VGND VPWR VGND sky130_ef_sc_hd__decap_12
X_0698_ _0215_ _0216_ _0217_ VGND VGND VPWR VPWR _0218_ sky130_fd_sc_hd__or3_1
X_1319_ clknet_4_2_0_clk _0101_ VGND VGND VPWR VPWR u_uart.clk_cnt\[3\] sky130_fd_sc_hd__dfxtp_1
XFILLER_0_2_83 VGND VGND VPWR VPWR sky130_fd_sc_hd__fill_1
XPHY_7 VGND VGND VPWR VPWR sky130_fd_sc_hd__decap_3
X_0621_ _0156_ _0158_ VGND VGND VPWR VPWR _0159_ sky130_fd_sc_hd__or2_1
XFILLER_0_25_213 VGND VGND VPWR VPWR sky130_fd_sc_hd__decap_4
X_1035_ u_uart.busy _0436_ VGND VGND VPWR VPWR _0473_ sky130_fd_sc_hd__nand2_2
XFILLER_0_17_51 VGND VGND VPWR VPWR sky130_fd_sc_hd__fill_2
X_1104_ _0523_ _0524_ _0525_ VGND VGND VPWR VPWR _0526_ sky130_fd_sc_hd__and3_1
XFILLER_0_33_83 VGND VGND VPWR VPWR sky130_fd_sc_hd__decap_6
XFILLER_0_31_205 VGND VGND VPWR VPWR sky130_fd_sc_hd__decap_4
X_0819_ _0307_ VGND VGND VPWR VPWR _0049_ sky130_fd_sc_hd__clkbuf_1
XFILLER_0_30_271 VGND VGND VPWR VPWR sky130_fd_sc_hd__fill_2
XFILLER_0_28_61 VPWR VGND VPWR VGND sky130_ef_sc_hd__decap_12
XFILLER_0_48_113 VPWR VGND VPWR VGND sky130_ef_sc_hd__decap_12
X_1018_ net76 _0459_ _0461_ _0456_ VGND VGND VPWR VPWR _0094_ sky130_fd_sc_hd__o211a_1
Xu_ro_bank.g_ro\[7\].u_ro.g_stg\[14\].u_inv_u_cell u_ro_bank.g_ro\[7\].u_ro.n\[13\]
+ VGND VGND VPWR VPWR u_ro_bank.g_ro\[7\].u_ro.n\[14\] sky130_fd_sc_hd__inv_1
XFILLER_0_40_29 VPWR VGND VPWR VGND sky130_ef_sc_hd__decap_12
XFILLER_0_4_29 VGND VGND VPWR VPWR sky130_fd_sc_hd__fill_2
XFILLER_0_5_279 VGND VGND VPWR VPWR sky130_fd_sc_hd__fill_1
XFILLER_0_30_40 VPWR VGND VPWR VGND sky130_ef_sc_hd__decap_12
XFILLER_0_39_71 VGND VGND VPWR VPWR sky130_fd_sc_hd__decap_6
XTAP_230 VGND VPWR sky130_fd_sc_hd__tapvpwrvgnd_1
XTAP_241 VGND VPWR sky130_fd_sc_hd__tapvpwrvgnd_1
XFILLER_0_30_95 VGND VGND VPWR VPWR sky130_fd_sc_hd__decap_4
XTAP_296 VGND VPWR sky130_fd_sc_hd__tapvpwrvgnd_1
XTAP_285 VGND VPWR sky130_fd_sc_hd__tapvpwrvgnd_1
XTAP_274 VGND VPWR sky130_fd_sc_hd__tapvpwrvgnd_1
XTAP_263 VGND VPWR sky130_fd_sc_hd__tapvpwrvgnd_1
XTAP_252 VGND VPWR sky130_fd_sc_hd__tapvpwrvgnd_1
XFILLER_0_42_108 VPWR VGND VPWR VGND sky130_ef_sc_hd__decap_12
X_1352_ clknet_4_5_0_clk _0134_ VGND VGND VPWR VPWR div\[19\] sky130_fd_sc_hd__dfxtp_1
X_1283_ clknet_4_15_0_clk _0065_ VGND VGND VPWR VPWR u_apt.cnt\[0\] sky130_fd_sc_hd__dfxtp_1
XFILLER_0_41_61 VPWR VGND VPWR VGND sky130_ef_sc_hd__decap_12
X_0998_ net29 _0440_ _0447_ _0372_ VGND VGND VPWR VPWR _0088_ sky130_fd_sc_hd__o211a_1
XFILLER_0_26_182 VGND VGND VPWR VPWR sky130_fd_sc_hd__decap_6
XFILLER_0_5_50 VGND VGND VPWR VPWR sky130_fd_sc_hd__decap_6
XFILLER_0_32_163 VGND VGND VPWR VPWR sky130_fd_sc_hd__fill_1
X_0921_ net65 _0356_ VGND VGND VPWR VPWR _0386_ sky130_fd_sc_hd__nand2_1
X_0783_ _0281_ _0274_ _0276_ _0278_ VGND VGND VPWR VPWR _0282_ sky130_fd_sc_hd__a31o_1
XFILLER_0_23_141 VGND VGND VPWR VPWR sky130_fd_sc_hd__decap_8
X_0852_ u_apt.idx\[10\] _0326_ _0331_ _0172_ VGND VGND VPWR VPWR _0058_ sky130_fd_sc_hd__o211a_1
X_1335_ clknet_4_4_0_clk _0117_ VGND VGND VPWR VPWR div\[2\] sky130_fd_sc_hd__dfxtp_1
X_1197_ _0592_ VGND VGND VPWR VPWR _0593_ sky130_fd_sc_hd__clkbuf_2
XFILLER_0_36_61 VPWR VGND VPWR VGND sky130_ef_sc_hd__decap_12
X_1266_ clknet_4_12_0_clk _0048_ VGND VGND VPWR VPWR u_apt.idx\[0\] sky130_fd_sc_hd__dfxtp_1
XFILLER_0_46_277 VPWR VGND VPWR VGND sky130_ef_sc_hd__decap_12
XFILLER_0_14_141 VPWR VGND VPWR VGND sky130_ef_sc_hd__decap_12
XFILLER_0_37_200 VGND VGND VPWR VPWR sky130_fd_sc_hd__fill_1
XFILLER_0_20_133 VGND VGND VPWR VPWR sky130_fd_sc_hd__decap_6
XFILLER_0_20_177 VPWR VGND VPWR VGND sky130_ef_sc_hd__decap_12
X_1120_ div\[5\] div\[4\] div\[6\] _0531_ VGND VGND VPWR VPWR _0537_ sky130_fd_sc_hd__and4_2
X_1051_ _0473_ _0484_ u_uart.clk_cnt\[6\] _0457_ VGND VGND VPWR VPWR _0485_ sky130_fd_sc_hd__a2bb2o_1
XFILLER_0_43_225 VPWR VGND VPWR VGND sky130_ef_sc_hd__decap_12
XFILLER_0_43_214 VGND VGND VPWR VPWR sky130_fd_sc_hd__fill_2
X_0904_ u_apt.cnt\[4\] _0365_ _0371_ _0372_ VGND VGND VPWR VPWR _0069_ sky130_fd_sc_hd__o211a_1
XFILLER_0_22_41 VPWR VGND VPWR VGND sky130_ef_sc_hd__decap_12
XFILLER_0_28_288 VGND VGND VPWR VPWR sky130_fd_sc_hd__decap_3
X_0697_ div\[21\] div\[20\] div\[23\] div\[22\] VGND VGND VPWR VPWR _0217_ sky130_fd_sc_hd__or4_1
XFILLER_0_11_111 VGND VGND VPWR VPWR sky130_fd_sc_hd__fill_1
X_0766_ _0267_ VGND VGND VPWR VPWR _0036_ sky130_fd_sc_hd__clkbuf_1
X_0835_ _0319_ VGND VGND VPWR VPWR _0053_ sky130_fd_sc_hd__clkbuf_1
XFILLER_0_37_3 VPWR VGND VPWR VGND sky130_ef_sc_hd__decap_12
X_1318_ clknet_4_2_0_clk _0100_ VGND VGND VPWR VPWR u_uart.clk_cnt\[2\] sky130_fd_sc_hd__dfxtp_1
X_1249_ clknet_4_0_0_clk _0033_ VGND VGND VPWR VPWR warm\[11\] sky130_fd_sc_hd__dfxtp_1
XFILLER_0_34_236 VGND VGND VPWR VPWR sky130_fd_sc_hd__fill_1
XPHY_8 VGND VGND VPWR VPWR sky130_fd_sc_hd__decap_3
XFILLER_0_25_225 VGND VGND VPWR VPWR sky130_fd_sc_hd__decap_8
X_0620_ bit_idx\[2\] _0157_ VGND VGND VPWR VPWR _0158_ sky130_fd_sc_hd__nand2_1
Xu_ro_bank.g_ro\[6\].u_ro.g_stg\[6\].u_inv_u_cell u_ro_bank.g_ro\[6\].u_ro.n\[5\]
+ VGND VGND VPWR VPWR u_ro_bank.g_ro\[6\].u_ro.n\[6\] sky130_fd_sc_hd__inv_1
X_1034_ net60 _0470_ _0472_ _0239_ VGND VGND VPWR VPWR _0099_ sky130_fd_sc_hd__a211oi_1
X_1103_ div\[1\] div\[0\] VGND VGND VPWR VPWR _0525_ sky130_fd_sc_hd__or2_1
XFILLER_0_16_269 VGND VGND VPWR VPWR sky130_fd_sc_hd__fill_2
X_0818_ _0305_ _0251_ _0306_ VGND VGND VPWR VPWR _0307_ sky130_fd_sc_hd__and3b_1
X_0749_ _0257_ _0251_ _0258_ VGND VGND VPWR VPWR _0259_ sky130_fd_sc_hd__and3b_1
Xu_ro_bank.g_ro\[6\].u_ro.g_stg\[11\].u_inv_u_cell u_ro_bank.g_ro\[6\].u_ro.n\[10\]
+ VGND VGND VPWR VPWR u_ro_bank.g_ro\[6\].u_ro.n\[11\] sky130_fd_sc_hd__inv_1
XFILLER_0_28_73 VGND VGND VPWR VPWR sky130_fd_sc_hd__decap_8
XFILLER_0_48_169 VPWR VGND VPWR VGND sky130_ef_sc_hd__decap_12
XFILLER_0_48_125 VPWR VGND VPWR VGND sky130_ef_sc_hd__decap_12
XFILLER_0_44_61 VGND VGND VPWR VPWR sky130_fd_sc_hd__fill_1
X_1017_ _0425_ _0460_ _0439_ VGND VGND VPWR VPWR _0461_ sky130_fd_sc_hd__a21o_1
XFILLER_0_8_83 VGND VGND VPWR VPWR sky130_fd_sc_hd__fill_1
XFILLER_0_8_94 VGND VGND VPWR VPWR sky130_fd_sc_hd__fill_1
XFILLER_0_39_169 VGND VGND VPWR VPWR sky130_fd_sc_hd__decap_3
XFILLER_0_5_225 VPWR VGND VPWR VGND sky130_ef_sc_hd__decap_12
XFILLER_0_5_203 VGND VGND VPWR VPWR sky130_fd_sc_hd__decap_4
XFILLER_0_30_52 VGND VGND VPWR VPWR sky130_fd_sc_hd__decap_4
XFILLER_0_30_85 VGND VGND VPWR VPWR sky130_fd_sc_hd__decap_6
XTAP_275 VGND VPWR sky130_fd_sc_hd__tapvpwrvgnd_1
XTAP_264 VGND VPWR sky130_fd_sc_hd__tapvpwrvgnd_1
XTAP_220 VGND VPWR sky130_fd_sc_hd__tapvpwrvgnd_1
XTAP_231 VGND VPWR sky130_fd_sc_hd__tapvpwrvgnd_1
XTAP_242 VGND VPWR sky130_fd_sc_hd__tapvpwrvgnd_1
XTAP_253 VGND VPWR sky130_fd_sc_hd__tapvpwrvgnd_1
XTAP_297 VGND VPWR sky130_fd_sc_hd__tapvpwrvgnd_1
XTAP_286 VGND VPWR sky130_fd_sc_hd__tapvpwrvgnd_1
XFILLER_0_36_117 VGND VGND VPWR VPWR sky130_fd_sc_hd__fill_1
X_1351_ clknet_4_5_0_clk _0133_ VGND VGND VPWR VPWR div\[18\] sky130_fd_sc_hd__dfxtp_1
Xu_ro_bank.g_ro\[5\].u_ro.g_stg\[2\].u_inv_u_cell u_ro_bank.g_ro\[5\].u_ro.n\[1\]
+ VGND VGND VPWR VPWR u_ro_bank.g_ro\[5\].u_ro.n\[2\] sky130_fd_sc_hd__inv_1
X_1282_ clknet_4_12_0_clk _0064_ VGND VGND VPWR VPWR u_apt.ref_bit sky130_fd_sc_hd__dfxtp_1
XFILLER_0_41_73 VPWR VGND VPWR VGND sky130_ef_sc_hd__decap_12
XFILLER_0_41_95 VPWR VGND VPWR VGND sky130_ef_sc_hd__decap_12
XFILLER_0_1_261 VPWR VGND VPWR VGND sky130_ef_sc_hd__decap_12
X_0997_ _0441_ _0446_ VGND VGND VPWR VPWR _0447_ sky130_fd_sc_hd__or2_1
XFILLER_0_24_109 VGND VGND VPWR VPWR sky130_fd_sc_hd__fill_1
XFILLER_0_46_29 VPWR VGND VPWR VGND sky130_ef_sc_hd__decap_12
X_0920_ _0236_ _0385_ VGND VGND VPWR VPWR _0072_ sky130_fd_sc_hd__nor2_1
X_0782_ u_rct.cnt\[1\] u_rct.cnt\[0\] VGND VGND VPWR VPWR _0281_ sky130_fd_sc_hd__nand2_1
XFILLER_0_11_32 VPWR VGND VPWR VGND sky130_ef_sc_hd__decap_12
X_0851_ _0330_ _0231_ u_apt.idx\[8\] net58 VGND VGND VPWR VPWR _0331_ sky130_fd_sc_hd__or4bb_1
X_1265_ clknet_4_12_0_clk _0047_ VGND VGND VPWR VPWR u_rct.fail sky130_fd_sc_hd__dfxtp_1
X_1334_ clknet_4_4_0_clk _0116_ VGND VGND VPWR VPWR div\[1\] sky130_fd_sc_hd__dfxtp_1
X_1196_ div\[25\] div\[27\] div\[26\] _0585_ VGND VGND VPWR VPWR _0592_ sky130_fd_sc_hd__and4_1
XFILLER_0_36_73 VGND VGND VPWR VPWR sky130_fd_sc_hd__decap_3
XFILLER_0_46_289 VGND VGND VPWR VPWR sky130_fd_sc_hd__fill_2
XFILLER_0_14_153 VPWR VGND VPWR VGND sky130_ef_sc_hd__decap_12
XFILLER_0_37_223 VGND VGND VPWR VPWR sky130_fd_sc_hd__fill_1
XFILLER_0_37_289 VGND VGND VPWR VPWR sky130_fd_sc_hd__fill_2
XFILLER_0_20_101 VGND VGND VPWR VPWR sky130_fd_sc_hd__decap_4
XFILLER_0_20_189 VGND VGND VPWR VPWR sky130_fd_sc_hd__decap_6
X_1050_ u_uart.clk_cnt\[6\] u_uart.clk_cnt\[5\] u_uart.clk_cnt\[4\] _0478_ VGND VGND
+ VPWR VPWR _0484_ sky130_fd_sc_hd__and4_2
XFILLER_0_43_237 VPWR VGND VPWR VGND sky130_ef_sc_hd__decap_12
XFILLER_0_22_53 VPWR VGND VPWR VGND sky130_ef_sc_hd__decap_12
X_0903_ _0165_ VGND VGND VPWR VPWR _0372_ sky130_fd_sc_hd__clkbuf_4
XFILLER_0_28_267 VGND VGND VPWR VPWR sky130_fd_sc_hd__decap_4
X_0834_ _0317_ _0251_ _0318_ VGND VGND VPWR VPWR _0319_ sky130_fd_sc_hd__and3b_1
X_0696_ div\[25\] div\[24\] div\[27\] div\[26\] VGND VGND VPWR VPWR _0216_ sky130_fd_sc_hd__or4_1
X_0765_ net81 _0237_ VGND VGND VPWR VPWR _0267_ sky130_fd_sc_hd__and2_1
XFILLER_0_47_94 VGND VGND VPWR VPWR sky130_fd_sc_hd__decap_8
X_1248_ clknet_4_0_0_clk _0032_ VGND VGND VPWR VPWR warm\[10\] sky130_fd_sc_hd__dfxtp_1
X_1317_ clknet_4_2_0_clk _0099_ VGND VGND VPWR VPWR u_uart.clk_cnt\[1\] sky130_fd_sc_hd__dfxtp_1
X_1179_ div\[22\] _0577_ VGND VGND VPWR VPWR _0580_ sky130_fd_sc_hd__or2_1
XFILLER_0_2_85 VPWR VGND VPWR VGND sky130_ef_sc_hd__decap_12
XFILLER_0_6_194 VGND VGND VPWR VPWR sky130_fd_sc_hd__fill_2
XFILLER_0_19_289 VGND VGND VPWR VPWR sky130_fd_sc_hd__fill_2
XPHY_9 VGND VGND VPWR VPWR sky130_fd_sc_hd__decap_3
XFILLER_0_4_109 VPWR VGND VPWR VGND sky130_ef_sc_hd__decap_12
XFILLER_0_25_259 VGND VGND VPWR VPWR sky130_fd_sc_hd__decap_6
X_1102_ _0520_ VGND VGND VPWR VPWR _0524_ sky130_fd_sc_hd__buf_2
XFILLER_0_17_64 VGND VGND VPWR VPWR sky130_fd_sc_hd__decap_8
XFILLER_0_33_41 VGND VGND VPWR VPWR sky130_fd_sc_hd__decap_4
X_1033_ u_uart.clk_cnt\[0\] _0425_ net60 VGND VGND VPWR VPWR _0472_ sky130_fd_sc_hd__a21oi_1
X_0817_ u_apt.idx\[0\] _0296_ u_apt.idx\[1\] VGND VGND VPWR VPWR _0306_ sky130_fd_sc_hd__a21o_1
XFILLER_0_3_164 VGND VGND VPWR VPWR sky130_fd_sc_hd__fill_1
X_0748_ warm\[6\] _0254_ VGND VGND VPWR VPWR _0258_ sky130_fd_sc_hd__or2_1
X_0679_ _0201_ _0202_ _0203_ VGND VGND VPWR VPWR _0204_ sky130_fd_sc_hd__and3_1
XFILLER_0_30_251 VGND VGND VPWR VPWR sky130_fd_sc_hd__fill_1
XFILLER_0_0_145 VGND VGND VPWR VPWR sky130_fd_sc_hd__fill_1
XFILLER_0_28_85 VPWR VGND VPWR VGND sky130_ef_sc_hd__decap_12
XFILLER_0_48_137 VGND VGND VPWR VPWR sky130_fd_sc_hd__decap_3
X_1016_ u_uart.bit_cnt\[3\] u_uart.bit_cnt\[0\] _0429_ VGND VGND VPWR VPWR _0460_
+ sky130_fd_sc_hd__o21ai_1
XFILLER_0_8_289 VGND VGND VPWR VPWR sky130_fd_sc_hd__fill_2
Xu_ro_bank.g_ro\[0\].u_ro.g_stg\[1\].u_inv_u_cell u_ro_bank.g_ro\[0\].u_ro.n\[0\]
+ VGND VGND VPWR VPWR u_ro_bank.g_ro\[0\].u_ro.n\[1\] sky130_fd_sc_hd__inv_1
XFILLER_0_5_237 VPWR VGND VPWR VGND sky130_ef_sc_hd__decap_12
XTAP_298 VGND VPWR sky130_fd_sc_hd__tapvpwrvgnd_1
XTAP_287 VGND VPWR sky130_fd_sc_hd__tapvpwrvgnd_1
XTAP_276 VGND VPWR sky130_fd_sc_hd__tapvpwrvgnd_1
XTAP_265 VGND VPWR sky130_fd_sc_hd__tapvpwrvgnd_1
XTAP_210 VGND VPWR sky130_fd_sc_hd__tapvpwrvgnd_1
XTAP_221 VGND VPWR sky130_fd_sc_hd__tapvpwrvgnd_1
XTAP_232 VGND VPWR sky130_fd_sc_hd__tapvpwrvgnd_1
XTAP_243 VGND VPWR sky130_fd_sc_hd__tapvpwrvgnd_1
XTAP_254 VGND VPWR sky130_fd_sc_hd__tapvpwrvgnd_1
XFILLER_0_12_3 VGND VGND VPWR VPWR sky130_fd_sc_hd__decap_8
XFILLER_0_29_192 VGND VGND VPWR VPWR sky130_fd_sc_hd__decap_3
XFILLER_0_44_195 VGND VGND VPWR VPWR sky130_fd_sc_hd__fill_1
Xu_ro_bank.g_ro\[7\].u_ro.g_stg\[10\].u_inv_u_cell u_ro_bank.g_ro\[7\].u_ro.n\[9\]
+ VGND VGND VPWR VPWR u_ro_bank.g_ro\[7\].u_ro.n\[10\] sky130_fd_sc_hd__inv_1
X_1350_ clknet_4_5_0_clk _0132_ VGND VGND VPWR VPWR div\[17\] sky130_fd_sc_hd__dfxtp_1
X_1281_ clknet_4_3_0_clk _0063_ VGND VGND VPWR VPWR u_apt.idx\[15\] sky130_fd_sc_hd__dfxtp_1
XFILLER_0_41_85 VGND VGND VPWR VPWR sky130_fd_sc_hd__decap_4
XFILLER_0_41_30 VPWR VGND VPWR VGND sky130_ef_sc_hd__decap_12
X_0996_ u_uart.tx_data\[2\] u_uart.shreg\[3\] _0424_ VGND VGND VPWR VPWR _0446_ sky130_fd_sc_hd__mux2_1
XFILLER_0_41_187 VGND VGND VPWR VPWR sky130_fd_sc_hd__decap_8
XFILLER_0_1_273 VGND VGND VPWR VPWR sky130_fd_sc_hd__decap_6
XFILLER_0_5_85 VGND VGND VPWR VPWR sky130_fd_sc_hd__fill_1
XFILLER_0_1_3 VPWR VGND VPWR VGND sky130_ef_sc_hd__decap_12
X_0850_ u_apt.idx\[11\] u_apt.idx\[10\] _0328_ _0329_ _0313_ VGND VGND VPWR VPWR _0330_
+ sky130_fd_sc_hd__o32a_1
X_0781_ net90 _0277_ _0280_ _0172_ VGND VGND VPWR VPWR _0038_ sky130_fd_sc_hd__o211a_1
XFILLER_0_11_44 VPWR VGND VPWR VGND sky130_ef_sc_hd__decap_12
XFILLER_0_11_99 VGND VGND VPWR VPWR sky130_fd_sc_hd__fill_1
X_1333_ clknet_4_4_0_clk _0115_ VGND VGND VPWR VPWR div\[0\] sky130_fd_sc_hd__dfxtp_1
X_1264_ clknet_4_12_0_clk _0046_ VGND VGND VPWR VPWR u_rct.last sky130_fd_sc_hd__dfxtp_1
X_1195_ _0591_ VGND VGND VPWR VPWR _0141_ sky130_fd_sc_hd__clkbuf_1
XFILLER_0_36_85 VPWR VGND VPWR VGND sky130_ef_sc_hd__decap_12
X_0979_ u_uart.clk_cnt\[9\] u_uart.clk_cnt\[8\] u_uart.clk_cnt\[1\] u_uart.clk_cnt\[0\]
+ VGND VGND VPWR VPWR _0432_ sky130_fd_sc_hd__nand4_1
XFILLER_0_14_165 VPWR VGND VPWR VGND sky130_ef_sc_hd__decap_12
Xu_ro_bank.g_ro\[7\].u_ro.g_stg\[6\].u_inv_u_cell u_ro_bank.g_ro\[7\].u_ro.n\[5\]
+ VGND VGND VPWR VPWR u_ro_bank.g_ro\[7\].u_ro.n\[6\] sky130_fd_sc_hd__inv_1
XFILLER_0_37_279 VGND VGND VPWR VPWR sky130_fd_sc_hd__fill_1
XFILLER_0_43_249 VPWR VGND VPWR VGND sky130_ef_sc_hd__decap_12
XFILLER_0_43_205 VGND VGND VPWR VPWR sky130_fd_sc_hd__decap_6
X_0902_ u_apt.cnt\[4\] _0356_ _0354_ _0370_ VGND VGND VPWR VPWR _0371_ sky130_fd_sc_hd__a22o_1
XFILLER_0_22_65 VPWR VGND VPWR VGND sky130_ef_sc_hd__decap_12
X_0833_ u_apt.idx\[4\] _0314_ u_apt.idx\[5\] VGND VGND VPWR VPWR _0318_ sky130_fd_sc_hd__a21o_1
X_0695_ div\[29\] div\[28\] div\[31\] div\[30\] VGND VGND VPWR VPWR _0215_ sky130_fd_sc_hd__or4_1
X_0764_ _0266_ VGND VGND VPWR VPWR _0035_ sky130_fd_sc_hd__clkbuf_1
X_1178_ _0579_ VGND VGND VPWR VPWR _0136_ sky130_fd_sc_hd__clkbuf_1
X_1247_ clknet_4_0_0_clk _0031_ VGND VGND VPWR VPWR warm\[9\] sky130_fd_sc_hd__dfxtp_1
X_1316_ clknet_4_2_0_clk _0098_ VGND VGND VPWR VPWR u_uart.clk_cnt\[0\] sky130_fd_sc_hd__dfxtp_1
XFILLER_0_2_97 VPWR VGND VPWR VGND sky130_ef_sc_hd__decap_12
XFILLER_0_19_235 VGND VGND VPWR VPWR sky130_fd_sc_hd__decap_4
XFILLER_0_27_290 VGND VGND VPWR VPWR sky130_fd_sc_hd__fill_1
XFILLER_0_25_238 VGND VGND VPWR VPWR sky130_fd_sc_hd__fill_2
XFILLER_0_33_260 VGND VGND VPWR VPWR sky130_fd_sc_hd__fill_2
X_1032_ _0470_ _0471_ VGND VGND VPWR VPWR _0098_ sky130_fd_sc_hd__nor2_1
X_1101_ div\[1\] div\[0\] VGND VGND VPWR VPWR _0523_ sky130_fd_sc_hd__nand2_1
X_0816_ _0231_ _0304_ VGND VGND VPWR VPWR _0305_ sky130_fd_sc_hd__nor2_1
X_0747_ warm\[6\] _0254_ VGND VGND VPWR VPWR _0257_ sky130_fd_sc_hd__and2_1
XFILLER_0_24_260 VGND VGND VPWR VPWR sky130_fd_sc_hd__decap_4
XFILLER_0_24_271 VGND VGND VPWR VPWR sky130_fd_sc_hd__fill_2
XFILLER_0_42_3 VPWR VGND VPWR VGND sky130_ef_sc_hd__decap_12
X_0678_ _0188_ _0157_ _0183_ bit_idx\[2\] VGND VGND VPWR VPWR _0203_ sky130_fd_sc_hd__o211ai_1
XFILLER_0_30_263 VGND VGND VPWR VPWR sky130_fd_sc_hd__decap_8
XFILLER_0_21_230 VGND VGND VPWR VPWR sky130_fd_sc_hd__decap_4
XFILLER_0_0_113 VPWR VGND VPWR VGND sky130_ef_sc_hd__decap_12
X_1015_ _0425_ _0436_ _0457_ VGND VGND VPWR VPWR _0459_ sky130_fd_sc_hd__a21oi_1
XFILLER_0_28_97 VGND VGND VPWR VPWR sky130_fd_sc_hd__fill_1
XFILLER_0_8_213 VPWR VGND VPWR VGND sky130_ef_sc_hd__decap_12
XFILLER_0_8_41 VPWR VGND VPWR VGND sky130_ef_sc_hd__decap_12
XFILLER_0_8_63 VGND VGND VPWR VPWR sky130_fd_sc_hd__fill_1
XFILLER_0_8_85 VGND VGND VPWR VPWR sky130_fd_sc_hd__fill_1
Xu_ro_bank.g_ro\[6\].u_ro.g_stg\[2\].u_inv_u_cell u_ro_bank.g_ro\[6\].u_ro.n\[1\]
+ VGND VGND VPWR VPWR u_ro_bank.g_ro\[6\].u_ro.n\[2\] sky130_fd_sc_hd__inv_1
XFILLER_0_39_127 VGND VGND VPWR VPWR sky130_fd_sc_hd__decap_3
XFILLER_0_38_193 VGND VGND VPWR VPWR sky130_fd_sc_hd__decap_3
XFILLER_0_38_160 VGND VGND VPWR VPWR sky130_fd_sc_hd__decap_3
XFILLER_0_5_249 VPWR VGND VPWR VGND sky130_ef_sc_hd__decap_12
XFILLER_0_30_76 VGND VGND VPWR VPWR sky130_fd_sc_hd__decap_8
XTAP_299 VGND VPWR sky130_fd_sc_hd__tapvpwrvgnd_1
XTAP_288 VGND VPWR sky130_fd_sc_hd__tapvpwrvgnd_1
XTAP_277 VGND VPWR sky130_fd_sc_hd__tapvpwrvgnd_1
XTAP_266 VGND VPWR sky130_fd_sc_hd__tapvpwrvgnd_1
XTAP_200 VGND VPWR sky130_fd_sc_hd__tapvpwrvgnd_1
XTAP_211 VGND VPWR sky130_fd_sc_hd__tapvpwrvgnd_1
XTAP_222 VGND VPWR sky130_fd_sc_hd__tapvpwrvgnd_1
XTAP_233 VGND VPWR sky130_fd_sc_hd__tapvpwrvgnd_1
XTAP_244 VGND VPWR sky130_fd_sc_hd__tapvpwrvgnd_1
XTAP_255 VGND VPWR sky130_fd_sc_hd__tapvpwrvgnd_1
XFILLER_0_44_141 VPWR VGND VPWR VGND sky130_ef_sc_hd__decap_12
XFILLER_0_35_185 VPWR VGND VPWR VGND sky130_ef_sc_hd__decap_12
X_1280_ clknet_4_3_0_clk _0062_ VGND VGND VPWR VPWR u_apt.idx\[14\] sky130_fd_sc_hd__dfxtp_1
XFILLER_0_41_133 VGND VGND VPWR VPWR sky130_fd_sc_hd__decap_4
XFILLER_0_41_111 VGND VGND VPWR VPWR sky130_fd_sc_hd__fill_1
XFILLER_0_41_42 VGND VGND VPWR VPWR sky130_fd_sc_hd__decap_6
X_0995_ net22 _0440_ _0445_ _0372_ VGND VGND VPWR VPWR _0087_ sky130_fd_sc_hd__o211a_1
Xu_ro_bank.g_ro\[2\].u_ro.g_stg\[5\].u_inv_u_cell u_ro_bank.g_ro\[2\].u_ro.n\[4\]
+ VGND VGND VPWR VPWR u_ro_bank.g_ro\[2\].u_ro.n\[5\] sky130_fd_sc_hd__inv_1
XFILLER_0_17_141 VGND VGND VPWR VPWR sky130_fd_sc_hd__decap_4
X_0780_ net90 _0279_ VGND VGND VPWR VPWR _0280_ sky130_fd_sc_hd__nand2_1
X_1194_ _0589_ _0535_ _0590_ VGND VGND VPWR VPWR _0591_ sky130_fd_sc_hd__and3b_1
XFILLER_0_36_97 VPWR VGND VPWR VGND sky130_ef_sc_hd__decap_12
X_1263_ clknet_4_7_0_clk _0045_ VGND VGND VPWR VPWR u_rct.cnt\[7\] sky130_fd_sc_hd__dfxtp_1
X_1332_ clknet_4_8_0_clk _0114_ VGND VGND VPWR VPWR net5 sky130_fd_sc_hd__dfxtp_1
XFILLER_0_14_177 VPWR VGND VPWR VGND sky130_ef_sc_hd__decap_12
X_0978_ u_uart.clk_cnt\[15\] u_uart.clk_cnt\[14\] u_uart.clk_cnt\[13\] u_uart.clk_cnt\[12\]
+ VGND VGND VPWR VPWR _0431_ sky130_fd_sc_hd__or4_1
XFILLER_0_37_225 VPWR VGND VPWR VGND sky130_ef_sc_hd__decap_12
XFILLER_0_9_160 VGND VGND VPWR VPWR sky130_fd_sc_hd__fill_1
XFILLER_0_28_247 VGND VGND VPWR VPWR sky130_fd_sc_hd__decap_4
X_0901_ u_apt.cnt\[4\] _0365_ VGND VGND VPWR VPWR _0370_ sky130_fd_sc_hd__nand2_1
X_0763_ net70 _0237_ VGND VGND VPWR VPWR _0266_ sky130_fd_sc_hd__and2_1
XFILLER_0_22_77 VGND VGND VPWR VPWR sky130_fd_sc_hd__decap_6
X_0832_ _0314_ _0316_ VGND VGND VPWR VPWR _0317_ sky130_fd_sc_hd__and2_1
X_1315_ clknet_4_8_0_clk _0097_ VGND VGND VPWR VPWR u_uart.bit_cnt\[3\] sky130_fd_sc_hd__dfxtp_2
X_0694_ u_vn.have VGND VGND VPWR VPWR _0214_ sky130_fd_sc_hd__inv_2
X_1177_ _0577_ _0535_ _0578_ VGND VGND VPWR VPWR _0579_ sky130_fd_sc_hd__and3b_1
X_1246_ clknet_4_3_0_clk net14 VGND VGND VPWR VPWR warm\[8\] sky130_fd_sc_hd__dfxtp_1
XFILLER_0_6_141 VGND VGND VPWR VPWR sky130_fd_sc_hd__fill_1
Xclkbuf_4_9_0_clk clknet_0_clk VGND VGND VPWR VPWR clknet_4_9_0_clk sky130_fd_sc_hd__clkbuf_8
X_1031_ u_uart.clk_cnt\[0\] _0425_ _0206_ VGND VGND VPWR VPWR _0471_ sky130_fd_sc_hd__o21ai_1
X_1100_ _0522_ VGND VGND VPWR VPWR _0115_ sky130_fd_sc_hd__clkbuf_1
X_0815_ u_apt.idx\[1\] u_apt.idx\[0\] VGND VGND VPWR VPWR _0304_ sky130_fd_sc_hd__nand2_1
XFILLER_0_31_209 VGND VGND VPWR VPWR sky130_fd_sc_hd__fill_1
XFILLER_0_3_111 VGND VGND VPWR VPWR sky130_fd_sc_hd__fill_1
X_0746_ _0256_ VGND VGND VPWR VPWR _0027_ sky130_fd_sc_hd__clkbuf_1
XFILLER_0_35_3 VGND VGND VPWR VPWR sky130_fd_sc_hd__decap_8
X_0677_ bit_idx\[2\] bit_idx\[0\] _0155_ byte_reg\[5\] VGND VGND VPWR VPWR _0202_
+ sky130_fd_sc_hd__a31o_1
Xu_ro_bank.g_ro\[1\].u_ro.g_stg\[1\].u_inv_u_cell u_ro_bank.g_ro\[1\].u_ro.n\[0\]
+ VGND VGND VPWR VPWR u_ro_bank.g_ro\[1\].u_ro.n\[1\] sky130_fd_sc_hd__inv_1
X_1229_ clknet_4_9_0_clk _0014_ VGND VGND VPWR VPWR byte_reg\[6\] sky130_fd_sc_hd__dfxtp_1
XFILLER_0_0_125 VPWR VGND VPWR VGND sky130_ef_sc_hd__decap_12
XFILLER_0_21_264 VGND VGND VPWR VPWR sky130_fd_sc_hd__decap_3
XFILLER_0_0_169 VPWR VGND VPWR VGND sky130_ef_sc_hd__decap_12
X_1014_ net26 _0440_ _0458_ _0456_ VGND VGND VPWR VPWR _0093_ sky130_fd_sc_hd__o211a_1
XFILLER_0_8_20 VGND VGND VPWR VPWR sky130_fd_sc_hd__fill_2
XFILLER_0_8_225 VGND VGND VPWR VPWR sky130_fd_sc_hd__decap_6
XFILLER_0_8_247 VGND VGND VPWR VPWR sky130_fd_sc_hd__decap_4
XFILLER_0_8_53 VGND VGND VPWR VPWR sky130_fd_sc_hd__decap_4
X_0729_ _0243_ VGND VGND VPWR VPWR _0023_ sky130_fd_sc_hd__clkbuf_1
XFILLER_0_14_78 VGND VGND VPWR VPWR sky130_fd_sc_hd__fill_1
XTAP_201 VGND VPWR sky130_fd_sc_hd__tapvpwrvgnd_1
XTAP_212 VGND VPWR sky130_fd_sc_hd__tapvpwrvgnd_1
XTAP_223 VGND VPWR sky130_fd_sc_hd__tapvpwrvgnd_1
XTAP_289 VGND VPWR sky130_fd_sc_hd__tapvpwrvgnd_1
XTAP_278 VGND VPWR sky130_fd_sc_hd__tapvpwrvgnd_1
XTAP_267 VGND VPWR sky130_fd_sc_hd__tapvpwrvgnd_1
XTAP_256 VGND VPWR sky130_fd_sc_hd__tapvpwrvgnd_1
XTAP_234 VGND VPWR sky130_fd_sc_hd__tapvpwrvgnd_1
XTAP_245 VGND VPWR sky130_fd_sc_hd__tapvpwrvgnd_1
XFILLER_0_36_109 VGND VGND VPWR VPWR sky130_fd_sc_hd__decap_8
XFILLER_0_29_150 VGND VGND VPWR VPWR sky130_fd_sc_hd__fill_2
XFILLER_0_44_153 VPWR VGND VPWR VGND sky130_ef_sc_hd__decap_12
XFILLER_0_27_109 VGND VGND VPWR VPWR sky130_fd_sc_hd__decap_3
XFILLER_0_35_197 VGND VGND VPWR VPWR sky130_fd_sc_hd__decap_8
XFILLER_0_18_109 VGND VGND VPWR VPWR sky130_fd_sc_hd__decap_6
XFILLER_0_41_54 VGND VGND VPWR VPWR sky130_fd_sc_hd__fill_2
X_0994_ _0441_ _0444_ VGND VGND VPWR VPWR _0445_ sky130_fd_sc_hd__or2_1
XFILLER_0_32_145 VPWR VGND VPWR VGND sky130_ef_sc_hd__decap_12
XFILLER_0_11_57 VPWR VGND VPWR VGND sky130_ef_sc_hd__decap_12
XFILLER_0_23_101 VGND VGND VPWR VPWR sky130_fd_sc_hd__decap_8
X_1331_ clknet_4_3_0_clk net39 VGND VGND VPWR VPWR u_uart.clk_cnt\[15\] sky130_fd_sc_hd__dfxtp_1
XFILLER_0_23_178 VGND VGND VPWR VPWR sky130_fd_sc_hd__fill_2
X_1193_ div\[25\] _0585_ div\[26\] VGND VGND VPWR VPWR _0590_ sky130_fd_sc_hd__a21o_1
X_1262_ clknet_4_13_0_clk _0044_ VGND VGND VPWR VPWR u_rct.cnt\[6\] sky130_fd_sc_hd__dfxtp_1
X_0977_ _0426_ _0427_ _0429_ VGND VGND VPWR VPWR _0430_ sky130_fd_sc_hd__or3b_1
XFILLER_0_14_189 VGND VGND VPWR VPWR sky130_fd_sc_hd__decap_4
XFILLER_0_45_281 VGND VGND VPWR VPWR sky130_fd_sc_hd__decap_8
XFILLER_0_45_270 VGND VGND VPWR VPWR sky130_fd_sc_hd__decap_8
XFILLER_0_37_237 VPWR VGND VPWR VGND sky130_ef_sc_hd__decap_12
XPHY_90 VGND VGND VPWR VPWR sky130_fd_sc_hd__decap_3
X_0900_ _0369_ VGND VGND VPWR VPWR _0068_ sky130_fd_sc_hd__clkbuf_1
X_0762_ _0265_ VGND VGND VPWR VPWR _0034_ sky130_fd_sc_hd__clkbuf_1
XFILLER_0_11_148 VGND VGND VPWR VPWR sky130_fd_sc_hd__fill_2
X_0693_ u_vn.first u_apt.b VGND VGND VPWR VPWR _0213_ sky130_fd_sc_hd__xnor2_1
X_0831_ u_apt.idx\[5\] u_apt.idx\[4\] VGND VGND VPWR VPWR _0316_ sky130_fd_sc_hd__and2_1
X_1314_ clknet_4_10_0_clk _0096_ VGND VGND VPWR VPWR u_uart.bit_cnt\[2\] sky130_fd_sc_hd__dfxtp_1
Xu_ro_bank.g_ro\[4\].u_ro.g_stg\[9\].u_inv_u_cell u_ro_bank.g_ro\[4\].u_ro.n\[8\]
+ VGND VGND VPWR VPWR u_ro_bank.g_ro\[4\].u_ro.n\[9\] sky130_fd_sc_hd__inv_1
X_1176_ div\[20\] _0571_ div\[21\] VGND VGND VPWR VPWR _0578_ sky130_fd_sc_hd__a21o_1
XFILLER_0_2_11 VGND VGND VPWR VPWR sky130_fd_sc_hd__fill_1
X_1245_ clknet_4_1_0_clk net16 VGND VGND VPWR VPWR warm\[7\] sky130_fd_sc_hd__dfxtp_1
XFILLER_0_6_186 VGND VGND VPWR VPWR sky130_fd_sc_hd__decap_8
XFILLER_0_42_251 VGND VGND VPWR VPWR sky130_fd_sc_hd__fill_1
XFILLER_0_6_197 VGND VGND VPWR VPWR sky130_fd_sc_hd__decap_3
XFILLER_0_25_207 VGND VGND VPWR VPWR sky130_fd_sc_hd__decap_3
Xu_ro_bank.g_ro\[7\].u_ro.g_stg\[2\].u_inv_u_cell u_ro_bank.g_ro\[7\].u_ro.n\[1\]
+ VGND VGND VPWR VPWR u_ro_bank.g_ro\[7\].u_ro.n\[2\] sky130_fd_sc_hd__inv_1
X_1030_ u_uart.clk_cnt\[0\] _0437_ _0469_ VGND VGND VPWR VPWR _0470_ sky130_fd_sc_hd__a21bo_1
X_0814_ net96 _0296_ _0303_ VGND VGND VPWR VPWR _0048_ sky130_fd_sc_hd__o21a_1
X_0676_ u_apt.rst_n VGND VGND VPWR VPWR _0201_ sky130_fd_sc_hd__clkbuf_4
X_0745_ _0254_ _0251_ _0255_ VGND VGND VPWR VPWR _0256_ sky130_fd_sc_hd__and3b_1
X_1228_ clknet_4_9_0_clk _0013_ VGND VGND VPWR VPWR byte_reg\[5\] sky130_fd_sc_hd__dfxtp_1
XFILLER_0_28_3 VGND VGND VPWR VPWR sky130_fd_sc_hd__fill_1
X_1159_ div\[15\] div\[14\] _0555_ _0564_ VGND VGND VPWR VPWR _0565_ sky130_fd_sc_hd__and4_1
XFILLER_0_0_137 VGND VGND VPWR VPWR sky130_fd_sc_hd__decap_3
X_1013_ net17 _0437_ _0457_ VGND VGND VPWR VPWR _0458_ sky130_fd_sc_hd__or3_1
XFILLER_0_12_287 VGND VGND VPWR VPWR sky130_fd_sc_hd__decap_4
X_0728_ _0241_ _0165_ _0242_ VGND VGND VPWR VPWR _0243_ sky130_fd_sc_hd__and3b_1
X_0659_ _0184_ _0187_ _0166_ VGND VGND VPWR VPWR _0009_ sky130_fd_sc_hd__o21a_1
Xclkbuf_4_8_0_clk clknet_0_clk VGND VGND VPWR VPWR clknet_4_8_0_clk sky130_fd_sc_hd__clkbuf_8
Xu_ro_bank.g_ro\[3\].u_ro.g_stg\[5\].u_inv_u_cell u_ro_bank.g_ro\[3\].u_ro.n\[4\]
+ VGND VGND VPWR VPWR u_ro_bank.g_ro\[3\].u_ro.n\[5\] sky130_fd_sc_hd__inv_1
XFILLER_0_30_56 VGND VGND VPWR VPWR sky130_fd_sc_hd__fill_1
XTAP_257 VGND VPWR sky130_fd_sc_hd__tapvpwrvgnd_1
XTAP_202 VGND VPWR sky130_fd_sc_hd__tapvpwrvgnd_1
XTAP_213 VGND VPWR sky130_fd_sc_hd__tapvpwrvgnd_1
XTAP_224 VGND VPWR sky130_fd_sc_hd__tapvpwrvgnd_1
XTAP_235 VGND VPWR sky130_fd_sc_hd__tapvpwrvgnd_1
XTAP_246 VGND VPWR sky130_fd_sc_hd__tapvpwrvgnd_1
XTAP_279 VGND VPWR sky130_fd_sc_hd__tapvpwrvgnd_1
XTAP_268 VGND VPWR sky130_fd_sc_hd__tapvpwrvgnd_1
XFILLER_0_44_165 VPWR VGND VPWR VGND sky130_ef_sc_hd__decap_12
X_0993_ u_uart.tx_data\[1\] u_uart.shreg\[2\] _0424_ VGND VGND VPWR VPWR _0444_ sky130_fd_sc_hd__mux2_1
XFILLER_0_25_89 VPWR VGND VPWR VGND sky130_ef_sc_hd__decap_12
XFILLER_0_41_113 VPWR VGND VPWR VGND sky130_ef_sc_hd__decap_12
XFILLER_0_5_11 VGND VGND VPWR VPWR sky130_fd_sc_hd__decap_3
XFILLER_0_10_3 VGND VGND VPWR VPWR sky130_fd_sc_hd__fill_1
XFILLER_0_17_110 VGND VGND VPWR VPWR sky130_fd_sc_hd__fill_2
XFILLER_0_32_157 VGND VGND VPWR VPWR sky130_fd_sc_hd__decap_6
XFILLER_0_11_69 VPWR VGND VPWR VGND sky130_ef_sc_hd__decap_12
XFILLER_0_23_113 VGND VGND VPWR VPWR sky130_fd_sc_hd__decap_8
X_1261_ clknet_4_12_0_clk _0043_ VGND VGND VPWR VPWR u_rct.cnt\[5\] sky130_fd_sc_hd__dfxtp_1
X_1330_ clknet_4_3_0_clk _0112_ VGND VGND VPWR VPWR u_uart.clk_cnt\[14\] sky130_fd_sc_hd__dfxtp_1
X_1192_ div\[25\] div\[26\] _0585_ VGND VGND VPWR VPWR _0589_ sky130_fd_sc_hd__and3_1
XFILLER_0_46_205 VGND VGND VPWR VPWR sky130_fd_sc_hd__fill_2
X_0976_ _0426_ u_uart.bit_cnt\[2\] _0428_ VGND VGND VPWR VPWR _0429_ sky130_fd_sc_hd__or3_1
XFILLER_0_37_249 VPWR VGND VPWR VGND sky130_ef_sc_hd__decap_12
XFILLER_0_20_105 VGND VGND VPWR VPWR sky130_fd_sc_hd__fill_1
Xu_ro_bank.g_ro\[2\].u_ro.g_stg\[1\].u_inv_u_cell u_ro_bank.g_ro\[2\].u_ro.n\[0\]
+ VGND VGND VPWR VPWR u_ro_bank.g_ro\[2\].u_ro.n\[1\] sky130_fd_sc_hd__inv_1
XPHY_91 VGND VGND VPWR VPWR sky130_fd_sc_hd__decap_3
XPHY_80 VGND VGND VPWR VPWR sky130_fd_sc_hd__decap_3
X_0830_ net40 _0314_ _0315_ VGND VGND VPWR VPWR _0052_ sky130_fd_sc_hd__a21oi_1
X_0761_ net72 _0237_ VGND VGND VPWR VPWR _0265_ sky130_fd_sc_hd__and2_1
X_0692_ _0212_ VGND VGND VPWR VPWR _0017_ sky130_fd_sc_hd__clkbuf_1
XFILLER_0_47_54 VGND VGND VPWR VPWR sky130_fd_sc_hd__fill_2
X_1313_ clknet_4_8_0_clk _0095_ VGND VGND VPWR VPWR u_uart.bit_cnt\[1\] sky130_fd_sc_hd__dfxtp_1
X_1244_ clknet_4_0_0_clk _0028_ VGND VGND VPWR VPWR warm\[6\] sky130_fd_sc_hd__dfxtp_1
X_1175_ div\[19\] div\[18\] _0565_ _0576_ VGND VGND VPWR VPWR _0577_ sky130_fd_sc_hd__and4_1
XFILLER_0_19_205 VGND VGND VPWR VPWR sky130_fd_sc_hd__decap_8
X_0959_ _0388_ _0414_ _0415_ u_apt.cnt\[9\] VGND VGND VPWR VPWR _0416_ sky130_fd_sc_hd__o31a_1
XFILLER_0_6_110 VGND VGND VPWR VPWR sky130_fd_sc_hd__decap_4
XFILLER_0_33_89 VGND VGND VPWR VPWR sky130_fd_sc_hd__fill_1
X_0813_ _0302_ _0231_ _0175_ VGND VGND VPWR VPWR _0303_ sky130_fd_sc_hd__o21a_1
XFILLER_0_3_113 VPWR VGND VPWR VGND sky130_ef_sc_hd__decap_12
XFILLER_0_16_219 VGND VGND VPWR VPWR sky130_fd_sc_hd__fill_1
X_0744_ warm\[5\] _0250_ VGND VGND VPWR VPWR _0255_ sky130_fd_sc_hd__or2_1
X_0675_ _0200_ VGND VGND VPWR VPWR _0012_ sky130_fd_sc_hd__clkbuf_1
X_1158_ _0563_ VGND VGND VPWR VPWR _0564_ sky130_fd_sc_hd__inv_2
X_1227_ clknet_4_11_0_clk _0012_ VGND VGND VPWR VPWR byte_reg\[4\] sky130_fd_sc_hd__dfxtp_1
X_1089_ net38 VGND VGND VPWR VPWR _0514_ sky130_fd_sc_hd__inv_2
XFILLER_0_30_233 VPWR VGND VPWR VGND sky130_ef_sc_hd__decap_12
XFILLER_0_15_274 VGND VGND VPWR VPWR sky130_fd_sc_hd__decap_6
X_1012_ _0438_ VGND VGND VPWR VPWR _0457_ sky130_fd_sc_hd__buf_2
XFILLER_0_12_200 VGND VGND VPWR VPWR sky130_fd_sc_hd__decap_6
X_0727_ warm\[0\] _0229_ warm\[1\] VGND VGND VPWR VPWR _0242_ sky130_fd_sc_hd__a21o_1
XFILLER_0_40_3 VGND VGND VPWR VPWR sky130_fd_sc_hd__decap_4
X_0658_ _0156_ _0185_ _0186_ net73 VGND VGND VPWR VPWR _0187_ sky130_fd_sc_hd__o31a_1
XFILLER_0_47_174 VPWR VGND VPWR VGND sky130_ef_sc_hd__decap_12
XFILLER_0_47_130 VPWR VGND VPWR VGND sky130_ef_sc_hd__decap_12
XFILLER_0_38_152 VGND VGND VPWR VPWR sky130_fd_sc_hd__decap_8
XFILLER_0_38_141 VGND VGND VPWR VPWR sky130_fd_sc_hd__fill_2
XTAP_269 VGND VPWR sky130_fd_sc_hd__tapvpwrvgnd_1
XTAP_258 VGND VPWR sky130_fd_sc_hd__tapvpwrvgnd_1
XTAP_203 VGND VPWR sky130_fd_sc_hd__tapvpwrvgnd_1
XTAP_214 VGND VPWR sky130_fd_sc_hd__tapvpwrvgnd_1
XTAP_225 VGND VPWR sky130_fd_sc_hd__tapvpwrvgnd_1
XTAP_236 VGND VPWR sky130_fd_sc_hd__tapvpwrvgnd_1
XTAP_247 VGND VPWR sky130_fd_sc_hd__tapvpwrvgnd_1
XFILLER_0_44_177 VPWR VGND VPWR VGND sky130_ef_sc_hd__decap_12
XFILLER_0_4_241 VGND VGND VPWR VPWR sky130_fd_sc_hd__decap_8
XFILLER_0_35_100 VGND VGND VPWR VPWR sky130_fd_sc_hd__fill_1
XFILLER_0_25_57 VGND VGND VPWR VPWR sky130_fd_sc_hd__fill_2
XFILLER_0_41_89 VGND VGND VPWR VPWR sky130_fd_sc_hd__fill_1
X_0992_ net43 _0440_ _0443_ _0372_ VGND VGND VPWR VPWR _0086_ sky130_fd_sc_hd__o211a_1
XFILLER_0_41_169 VGND VGND VPWR VPWR sky130_fd_sc_hd__fill_2
XFILLER_0_41_125 VGND VGND VPWR VPWR sky130_fd_sc_hd__decap_4
XFILLER_0_1_200 VGND VGND VPWR VPWR sky130_fd_sc_hd__decap_3
Xclkbuf_4_7_0_clk clknet_0_clk VGND VGND VPWR VPWR clknet_4_7_0_clk sky130_fd_sc_hd__clkbuf_8
XFILLER_0_5_89 VPWR VGND VPWR VGND sky130_ef_sc_hd__decap_12
Xu_ro_bank.g_ro\[5\].u_ro.g_stg\[9\].u_inv_u_cell u_ro_bank.g_ro\[5\].u_ro.n\[8\]
+ VGND VGND VPWR VPWR u_ro_bank.g_ro\[5\].u_ro.n\[9\] sky130_fd_sc_hd__inv_1
X_1191_ net85 _0585_ _0588_ VGND VGND VPWR VPWR _0140_ sky130_fd_sc_hd__o21a_1
X_1260_ clknet_4_13_0_clk _0042_ VGND VGND VPWR VPWR u_rct.cnt\[4\] sky130_fd_sc_hd__dfxtp_1
XFILLER_0_46_239 VPWR VGND VPWR VGND sky130_ef_sc_hd__decap_12
X_0975_ u_uart.bit_cnt\[1\] u_uart.bit_cnt\[0\] VGND VGND VPWR VPWR _0428_ sky130_fd_sc_hd__or2_1
XFILLER_0_14_136 VGND VGND VPWR VPWR sky130_fd_sc_hd__decap_4
XFILLER_0_37_217 VGND VGND VPWR VPWR sky130_fd_sc_hd__decap_6
XFILLER_0_9_130 VGND VGND VPWR VPWR sky130_fd_sc_hd__fill_1
XFILLER_0_20_139 VGND VGND VPWR VPWR sky130_fd_sc_hd__fill_1
XPHY_92 VGND VGND VPWR VPWR sky130_fd_sc_hd__decap_3
XPHY_81 VGND VGND VPWR VPWR sky130_fd_sc_hd__decap_3
XPHY_70 VGND VGND VPWR VPWR sky130_fd_sc_hd__decap_3
X_0760_ _0264_ VGND VGND VPWR VPWR _0033_ sky130_fd_sc_hd__clkbuf_1
X_0691_ _0201_ _0159_ _0211_ VGND VGND VPWR VPWR _0212_ sky130_fd_sc_hd__and3_1
X_1174_ _0575_ VGND VGND VPWR VPWR _0576_ sky130_fd_sc_hd__inv_2
X_1312_ clknet_4_8_0_clk _0094_ VGND VGND VPWR VPWR u_uart.bit_cnt\[0\] sky130_fd_sc_hd__dfxtp_1
X_1243_ clknet_4_0_0_clk _0027_ VGND VGND VPWR VPWR warm\[5\] sky130_fd_sc_hd__dfxtp_1
XFILLER_0_19_239 VGND VGND VPWR VPWR sky130_fd_sc_hd__fill_1
XFILLER_0_42_253 VPWR VGND VPWR VGND sky130_ef_sc_hd__decap_12
X_0958_ _0387_ _0412_ VGND VGND VPWR VPWR _0415_ sky130_fd_sc_hd__and2b_1
X_0889_ _0175_ _0360_ VGND VGND VPWR VPWR _0361_ sky130_fd_sc_hd__and2_1
XFILLER_0_6_166 VGND VGND VPWR VPWR sky130_fd_sc_hd__fill_2
X_0812_ u_apt.idx\[0\] VGND VGND VPWR VPWR _0302_ sky130_fd_sc_hd__inv_2
XFILLER_0_3_125 VGND VGND VPWR VPWR sky130_fd_sc_hd__decap_6
X_0743_ warm\[5\] warm\[4\] _0247_ VGND VGND VPWR VPWR _0254_ sky130_fd_sc_hd__and3_1
X_0674_ _0175_ _0199_ VGND VGND VPWR VPWR _0200_ sky130_fd_sc_hd__and2_1
X_1157_ div\[17\] div\[16\] VGND VGND VPWR VPWR _0563_ sky130_fd_sc_hd__nand2_1
X_1226_ clknet_4_14_0_clk _0011_ VGND VGND VPWR VPWR byte_reg\[3\] sky130_fd_sc_hd__dfxtp_1
Xu_ro_bank.g_ro\[4\].u_ro.g_stg\[5\].u_inv_u_cell u_ro_bank.g_ro\[4\].u_ro.n\[4\]
+ VGND VGND VPWR VPWR u_ro_bank.g_ro\[4\].u_ro.n\[5\] sky130_fd_sc_hd__inv_1
X_1088_ _0513_ VGND VGND VPWR VPWR _0112_ sky130_fd_sc_hd__clkbuf_1
XFILLER_0_30_289 VGND VGND VPWR VPWR sky130_fd_sc_hd__fill_2
XFILLER_0_30_245 VGND VGND VPWR VPWR sky130_fd_sc_hd__decap_6
XFILLER_0_30_223 VGND VGND VPWR VPWR sky130_fd_sc_hd__decap_4
XFILLER_0_30_201 VGND VGND VPWR VPWR sky130_fd_sc_hd__fill_1
XFILLER_0_21_223 VGND VGND VPWR VPWR sky130_fd_sc_hd__fill_1
XFILLER_0_21_256 VGND VGND VPWR VPWR sky130_fd_sc_hd__decap_8
X_1011_ net27 _0440_ _0455_ _0456_ VGND VGND VPWR VPWR _0092_ sky130_fd_sc_hd__o211a_1
XFILLER_0_48_109 VGND VGND VPWR VPWR sky130_fd_sc_hd__decap_3
X_0726_ warm\[1\] warm\[0\] _0229_ VGND VGND VPWR VPWR _0241_ sky130_fd_sc_hd__and3_1
XFILLER_0_33_3 VGND VGND VPWR VPWR sky130_fd_sc_hd__fill_1
X_0657_ _0157_ bit_idx\[2\] VGND VGND VPWR VPWR _0186_ sky130_fd_sc_hd__and2b_1
X_1209_ _0593_ _0598_ div\[30\] VGND VGND VPWR VPWR _0602_ sky130_fd_sc_hd__a21o_1
XFILLER_0_47_186 VPWR VGND VPWR VGND sky130_ef_sc_hd__decap_12
XFILLER_0_47_142 VPWR VGND VPWR VGND sky130_ef_sc_hd__decap_12
XFILLER_0_7_272 VGND VGND VPWR VPWR sky130_fd_sc_hd__decap_8
XFILLER_0_38_197 VGND VGND VPWR VPWR sky130_fd_sc_hd__decap_8
XFILLER_0_38_186 VGND VGND VPWR VPWR sky130_fd_sc_hd__decap_3
XFILLER_0_38_120 VGND VGND VPWR VPWR sky130_fd_sc_hd__fill_1
XFILLER_0_14_15 VGND VGND VPWR VPWR sky130_fd_sc_hd__fill_2
XFILLER_0_14_26 VGND VGND VPWR VPWR sky130_fd_sc_hd__fill_2
XTAP_259 VGND VPWR sky130_fd_sc_hd__tapvpwrvgnd_1
XTAP_204 VGND VPWR sky130_fd_sc_hd__tapvpwrvgnd_1
XTAP_215 VGND VPWR sky130_fd_sc_hd__tapvpwrvgnd_1
XTAP_226 VGND VPWR sky130_fd_sc_hd__tapvpwrvgnd_1
XTAP_237 VGND VPWR sky130_fd_sc_hd__tapvpwrvgnd_1
XTAP_248 VGND VPWR sky130_fd_sc_hd__tapvpwrvgnd_1
XFILLER_0_44_189 VGND VGND VPWR VPWR sky130_fd_sc_hd__decap_6
XFILLER_0_4_253 VPWR VGND VPWR VGND sky130_ef_sc_hd__decap_12
X_0709_ _0227_ _0228_ VGND VGND VPWR VPWR _0229_ sky130_fd_sc_hd__nor2_2
XFILLER_0_41_57 VGND VGND VPWR VPWR sky130_fd_sc_hd__fill_1
X_0991_ _0441_ _0442_ VGND VGND VPWR VPWR _0443_ sky130_fd_sc_hd__or2_1
XFILLER_0_41_137 VGND VGND VPWR VPWR sky130_fd_sc_hd__fill_1
XFILLER_0_1_289 VGND VGND VPWR VPWR sky130_fd_sc_hd__fill_2
Xu_ro_bank.g_ro\[3\].u_ro.g_stg\[1\].u_inv_u_cell u_ro_bank.g_ro\[3\].u_ro.n\[0\]
+ VGND VGND VPWR VPWR u_ro_bank.g_ro\[3\].u_ro.n\[1\] sky130_fd_sc_hd__inv_1
XFILLER_0_5_57 VPWR VGND VPWR VGND sky130_ef_sc_hd__decap_12
XFILLER_0_32_137 VGND VGND VPWR VPWR sky130_fd_sc_hd__decap_3
XFILLER_0_40_192 VGND VGND VPWR VPWR sky130_fd_sc_hd__decap_4
XFILLER_0_48_281 VGND VGND VPWR VPWR sky130_fd_sc_hd__decap_8
XFILLER_0_31_181 VPWR VGND VPWR VGND sky130_ef_sc_hd__decap_12
X_1190_ div\[25\] _0585_ _0524_ VGND VGND VPWR VPWR _0588_ sky130_fd_sc_hd__a21boi_1
XTAP_98 VGND VPWR sky130_fd_sc_hd__tapvpwrvgnd_1
XFILLER_0_39_281 VGND VGND VPWR VPWR sky130_fd_sc_hd__decap_8
X_0974_ u_uart.busy VGND VGND VPWR VPWR _0427_ sky130_fd_sc_hd__inv_2
XPHY_82 VGND VGND VPWR VPWR sky130_fd_sc_hd__decap_3
XPHY_71 VGND VGND VPWR VPWR sky130_fd_sc_hd__decap_3
XFILLER_0_22_15 VPWR VGND VPWR VGND sky130_ef_sc_hd__decap_12
XFILLER_0_28_218 VPWR VGND VPWR VGND sky130_ef_sc_hd__decap_12
XPHY_60 VGND VGND VPWR VPWR sky130_fd_sc_hd__decap_3
XPHY_93 VGND VGND VPWR VPWR sky130_fd_sc_hd__decap_3
XFILLER_0_36_251 VGND VGND VPWR VPWR sky130_fd_sc_hd__fill_1
Xclkbuf_4_6_0_clk clknet_0_clk VGND VGND VPWR VPWR clknet_4_6_0_clk sky130_fd_sc_hd__clkbuf_8
X_0690_ _0157_ bit_idx\[0\] _0155_ bit_idx\[2\] VGND VGND VPWR VPWR _0211_ sky130_fd_sc_hd__a31o_1
XFILLER_0_47_45 VGND VGND VPWR VPWR sky130_fd_sc_hd__fill_1
XFILLER_0_11_129 VGND VGND VPWR VPWR sky130_fd_sc_hd__decap_3
X_1311_ clknet_4_8_0_clk _0093_ VGND VGND VPWR VPWR u_uart.shreg\[7\] sky130_fd_sc_hd__dfxtp_1
X_1173_ div\[21\] div\[20\] VGND VGND VPWR VPWR _0575_ sky130_fd_sc_hd__nand2_1
X_1242_ clknet_4_0_0_clk _0026_ VGND VGND VPWR VPWR warm\[4\] sky130_fd_sc_hd__dfxtp_1
XFILLER_0_6_101 VGND VGND VPWR VPWR sky130_fd_sc_hd__fill_1
XFILLER_0_19_218 VGND VGND VPWR VPWR sky130_fd_sc_hd__decap_6
XFILLER_0_42_265 VPWR VGND VPWR VGND sky130_ef_sc_hd__decap_12
XFILLER_0_42_221 VPWR VGND VPWR VGND sky130_ef_sc_hd__decap_12
X_0888_ u_apt.cnt\[1\] _0356_ _0354_ _0359_ VGND VGND VPWR VPWR _0360_ sky130_fd_sc_hd__a22o_1
X_0957_ _0410_ _0413_ u_apt.cnt\[4\] _0367_ VGND VGND VPWR VPWR _0414_ sky130_fd_sc_hd__o211a_1
XFILLER_0_27_284 VGND VGND VPWR VPWR sky130_fd_sc_hd__decap_6
XFILLER_0_10_151 VPWR VGND VPWR VGND sky130_ef_sc_hd__decap_12
XFILLER_0_17_15 VPWR VGND VPWR VGND sky130_ef_sc_hd__decap_12
X_0811_ net11 _0301_ _0166_ VGND VGND VPWR VPWR _0047_ sky130_fd_sc_hd__o21a_1
X_0742_ _0253_ VGND VGND VPWR VPWR _0026_ sky130_fd_sc_hd__clkbuf_1
X_0673_ byte_reg\[4\] _0176_ _0178_ _0198_ VGND VGND VPWR VPWR _0199_ sky130_fd_sc_hd__a22o_1
XFILLER_0_24_232 VPWR VGND VPWR VGND sky130_ef_sc_hd__decap_12
X_1156_ net84 _0559_ _0562_ _0521_ VGND VGND VPWR VPWR _0131_ sky130_fd_sc_hd__o211a_1
X_1087_ _0165_ _0511_ _0512_ VGND VGND VPWR VPWR _0513_ sky130_fd_sc_hd__and3_1
X_1225_ clknet_4_11_0_clk _0010_ VGND VGND VPWR VPWR byte_reg\[2\] sky130_fd_sc_hd__dfxtp_1
X_1010_ _0165_ VGND VGND VPWR VPWR _0456_ sky130_fd_sc_hd__clkbuf_4
X_0725_ net51 _0229_ _0240_ VGND VGND VPWR VPWR _0022_ sky130_fd_sc_hd__o21a_1
X_0656_ bit_idx\[2\] _0157_ VGND VGND VPWR VPWR _0185_ sky130_fd_sc_hd__and2b_1
X_1208_ net99 VGND VGND VPWR VPWR _0601_ sky130_fd_sc_hd__inv_2
XFILLER_0_26_3 VPWR VGND VPWR VGND sky130_ef_sc_hd__decap_12
XFILLER_0_47_154 VPWR VGND VPWR VGND sky130_ef_sc_hd__decap_12
X_1139_ div\[11\] _0548_ VGND VGND VPWR VPWR _0551_ sky130_fd_sc_hd__and2_1
XFILLER_0_47_198 VPWR VGND VPWR VGND sky130_ef_sc_hd__decap_12
XFILLER_0_14_38 VGND VGND VPWR VPWR sky130_fd_sc_hd__decap_8
XFILLER_0_30_15 VPWR VGND VPWR VGND sky130_ef_sc_hd__decap_12
Xu_ro_bank.g_ro\[6\].u_ro.g_stg\[9\].u_inv_u_cell u_ro_bank.g_ro\[6\].u_ro.n\[8\]
+ VGND VGND VPWR VPWR u_ro_bank.g_ro\[6\].u_ro.n\[9\] sky130_fd_sc_hd__inv_1
XTAP_205 VGND VPWR sky130_fd_sc_hd__tapvpwrvgnd_1
Xhold1 hold1/A VGND VGND VPWR VPWR net7 sky130_fd_sc_hd__dlygate4sd3_1
XTAP_216 VGND VPWR sky130_fd_sc_hd__tapvpwrvgnd_1
XTAP_227 VGND VPWR sky130_fd_sc_hd__tapvpwrvgnd_1
XTAP_238 VGND VPWR sky130_fd_sc_hd__tapvpwrvgnd_1
XTAP_249 VGND VPWR sky130_fd_sc_hd__tapvpwrvgnd_1
XFILLER_0_4_265 VPWR VGND VPWR VGND sky130_ef_sc_hd__decap_12
XFILLER_0_29_165 VGND VGND VPWR VPWR sky130_fd_sc_hd__decap_3
X_0708_ warm\[15\] warm\[14\] warm\[13\] warm\[12\] VGND VGND VPWR VPWR _0228_ sky130_fd_sc_hd__or4_1
Xu_ro_bank.g_ro\[6\].u_ro.g_stg\[14\].u_inv_u_cell u_ro_bank.g_ro\[6\].u_ro.n\[13\]
+ VGND VGND VPWR VPWR u_ro_bank.g_ro\[6\].u_ro.n\[14\] sky130_fd_sc_hd__inv_1
X_0639_ _0165_ VGND VGND VPWR VPWR _0172_ sky130_fd_sc_hd__clkbuf_4
XFILLER_0_35_113 VGND VGND VPWR VPWR sky130_fd_sc_hd__decap_3
XFILLER_0_25_15 VPWR VGND VPWR VGND sky130_ef_sc_hd__decap_12
X_0990_ u_uart.tx_data\[0\] u_uart.shreg\[1\] _0424_ VGND VGND VPWR VPWR _0442_ sky130_fd_sc_hd__mux2_1
XFILLER_0_5_69 VPWR VGND VPWR VGND sky130_ef_sc_hd__decap_12
XFILLER_0_1_279 VGND VGND VPWR VPWR sky130_fd_sc_hd__fill_1
XFILLER_0_17_102 VGND VGND VPWR VPWR sky130_fd_sc_hd__decap_8
XFILLER_0_17_113 VGND VGND VPWR VPWR sky130_fd_sc_hd__decap_3
XFILLER_0_31_193 VPWR VGND VPWR VGND sky130_ef_sc_hd__decap_12
XFILLER_0_23_149 VGND VGND VPWR VPWR sky130_fd_sc_hd__decap_3
XFILLER_0_36_25 VGND VGND VPWR VPWR sky130_fd_sc_hd__decap_3
XTAP_99 VGND VPWR sky130_fd_sc_hd__tapvpwrvgnd_1
X_0973_ u_uart.bit_cnt\[3\] VGND VGND VPWR VPWR _0426_ sky130_fd_sc_hd__inv_2
XPHY_94 VGND VGND VPWR VPWR sky130_fd_sc_hd__decap_3
XPHY_83 VGND VGND VPWR VPWR sky130_fd_sc_hd__decap_3
XPHY_72 VGND VGND VPWR VPWR sky130_fd_sc_hd__decap_3
XPHY_61 VGND VGND VPWR VPWR sky130_fd_sc_hd__decap_3
Xu_ro_bank.g_ro\[5\].u_ro.g_stg\[5\].u_inv_u_cell u_ro_bank.g_ro\[5\].u_ro.n\[4\]
+ VGND VGND VPWR VPWR u_ro_bank.g_ro\[5\].u_ro.n\[5\] sky130_fd_sc_hd__inv_1
XFILLER_0_22_27 VGND VGND VPWR VPWR sky130_fd_sc_hd__fill_1
XPHY_50 VGND VGND VPWR VPWR sky130_fd_sc_hd__decap_3
XFILLER_0_47_68 VPWR VGND VPWR VGND sky130_ef_sc_hd__decap_12
X_1310_ clknet_4_10_0_clk _0092_ VGND VGND VPWR VPWR u_uart.shreg\[6\] sky130_fd_sc_hd__dfxtp_1
X_1241_ clknet_4_1_0_clk _0025_ VGND VGND VPWR VPWR warm\[3\] sky130_fd_sc_hd__dfxtp_1
X_1172_ net82 _0571_ _0574_ VGND VGND VPWR VPWR _0135_ sky130_fd_sc_hd__o21a_1
XFILLER_0_2_59 VPWR VGND VPWR VGND sky130_ef_sc_hd__decap_12
XFILLER_0_2_15 VPWR VGND VPWR VGND sky130_ef_sc_hd__decap_12
X_0956_ _0411_ _0358_ _0362_ _0412_ VGND VGND VPWR VPWR _0413_ sky130_fd_sc_hd__nor4_1
XFILLER_0_12_60 VPWR VGND VPWR VGND sky130_ef_sc_hd__decap_12
XFILLER_0_42_277 VPWR VGND VPWR VGND sky130_ef_sc_hd__decap_12
XFILLER_0_42_233 VPWR VGND VPWR VGND sky130_ef_sc_hd__decap_12
X_0887_ _0357_ _0358_ VGND VGND VPWR VPWR _0359_ sky130_fd_sc_hd__and2_1
XFILLER_0_10_163 VPWR VGND VPWR VGND sky130_ef_sc_hd__decap_12
XFILLER_0_33_222 VGND VGND VPWR VPWR sky130_fd_sc_hd__fill_2
XFILLER_0_17_27 VPWR VGND VPWR VGND sky130_ef_sc_hd__decap_12
X_0810_ u_rct.cnt\[7\] u_rct.cnt\[6\] _0300_ _0296_ _0276_ VGND VGND VPWR VPWR _0301_
+ sky130_fd_sc_hd__o311a_1
XFILLER_0_3_105 VGND VGND VPWR VPWR sky130_fd_sc_hd__decap_6
X_0741_ _0250_ _0251_ _0252_ VGND VGND VPWR VPWR _0253_ sky130_fd_sc_hd__and3b_1
X_0672_ u_vn.o byte_reg\[4\] _0197_ VGND VGND VPWR VPWR _0198_ sky130_fd_sc_hd__mux2_1
XFILLER_0_24_244 VGND VGND VPWR VPWR sky130_fd_sc_hd__fill_2
X_1224_ clknet_4_11_0_clk _0009_ VGND VGND VPWR VPWR byte_reg\[1\] sky130_fd_sc_hd__dfxtp_1
X_1155_ net84 _0559_ VGND VGND VPWR VPWR _0562_ sky130_fd_sc_hd__nand2_1
X_1086_ u_uart.clk_cnt\[14\] u_uart.clk_cnt\[13\] _0437_ _0504_ VGND VGND VPWR VPWR
+ _0512_ sky130_fd_sc_hd__nand4_1
X_0939_ _0398_ _0352_ _0374_ _0399_ VGND VGND VPWR VPWR _0400_ sky130_fd_sc_hd__o22a_1
XFILLER_0_2_171 VGND VGND VPWR VPWR sky130_fd_sc_hd__fill_1
Xclkbuf_4_5_0_clk clknet_0_clk VGND VGND VPWR VPWR clknet_4_5_0_clk sky130_fd_sc_hd__clkbuf_8
XFILLER_0_21_247 VGND VGND VPWR VPWR sky130_fd_sc_hd__fill_1
XFILLER_0_28_37 VGND VGND VPWR VPWR sky130_fd_sc_hd__decap_4
XFILLER_0_8_14 VGND VGND VPWR VPWR sky130_fd_sc_hd__decap_3
XFILLER_0_12_269 VGND VGND VPWR VPWR sky130_fd_sc_hd__fill_2
X_0724_ net51 _0229_ _0239_ VGND VGND VPWR VPWR _0240_ sky130_fd_sc_hd__a21oi_1
X_0655_ bit_idx\[2\] _0157_ _0183_ u_vn.o VGND VGND VPWR VPWR _0184_ sky130_fd_sc_hd__and4bb_1
X_1207_ _0600_ VGND VGND VPWR VPWR _0144_ sky130_fd_sc_hd__clkbuf_1
XFILLER_0_19_3 VPWR VGND VPWR VGND sky130_ef_sc_hd__decap_12
XFILLER_0_47_166 VGND VGND VPWR VPWR sky130_fd_sc_hd__fill_2
XFILLER_0_47_111 VGND VGND VPWR VPWR sky130_fd_sc_hd__fill_1
XFILLER_0_34_80 VGND VGND VPWR VPWR sky130_fd_sc_hd__decap_4
X_1138_ _0550_ VGND VGND VPWR VPWR _0125_ sky130_fd_sc_hd__clkbuf_1
X_1069_ _0424_ _0498_ _0438_ VGND VGND VPWR VPWR _0499_ sky130_fd_sc_hd__a21o_1
Xu_ro_bank.g_ro\[5\].u_ro.g_stg\[11\].u_inv_u_cell u_ro_bank.g_ro\[5\].u_ro.n\[10\]
+ VGND VGND VPWR VPWR u_ro_bank.g_ro\[5\].u_ro.n\[11\] sky130_fd_sc_hd__inv_1
Xu_ro_bank.g_ro\[4\].u_ro.g_stg\[1\].u_inv_u_cell u_ro_bank.g_ro\[4\].u_ro.n\[0\]
+ VGND VGND VPWR VPWR u_ro_bank.g_ro\[4\].u_ro.n\[1\] sky130_fd_sc_hd__inv_1
XFILLER_0_30_27 VGND VGND VPWR VPWR sky130_fd_sc_hd__fill_1
XTAP_206 VGND VPWR sky130_fd_sc_hd__tapvpwrvgnd_1
XTAP_217 VGND VPWR sky130_fd_sc_hd__tapvpwrvgnd_1
XTAP_228 VGND VPWR sky130_fd_sc_hd__tapvpwrvgnd_1
XTAP_239 VGND VPWR sky130_fd_sc_hd__tapvpwrvgnd_1
Xhold2 u_rst_sync.sr\[0\] VGND VGND VPWR VPWR net8 sky130_fd_sc_hd__dlygate4sd3_1
XFILLER_0_29_111 VGND VGND VPWR VPWR sky130_fd_sc_hd__fill_1
XFILLER_0_4_277 VPWR VGND VPWR VGND sky130_ef_sc_hd__decap_12
X_0707_ warm\[11\] warm\[10\] warm\[9\] warm\[8\] VGND VGND VPWR VPWR _0227_ sky130_fd_sc_hd__or4_1
X_0638_ byte_reg\[5\] _0163_ VGND VGND VPWR VPWR _0171_ sky130_fd_sc_hd__or2_1
XFILLER_0_29_91 VPWR VGND VPWR VGND sky130_ef_sc_hd__decap_12
XFILLER_0_0_81 VGND VGND VPWR VPWR sky130_fd_sc_hd__decap_3
XFILLER_0_8_3 VGND VGND VPWR VPWR sky130_fd_sc_hd__decap_8
XFILLER_0_25_27 VPWR VGND VPWR VGND sky130_ef_sc_hd__decap_12
XFILLER_0_41_15 VGND VGND VPWR VPWR sky130_fd_sc_hd__fill_1
XFILLER_0_1_225 VPWR VGND VPWR VGND sky130_ef_sc_hd__decap_12
XFILLER_0_32_128 VGND VGND VPWR VPWR sky130_fd_sc_hd__fill_1
XFILLER_0_48_250 VGND VGND VPWR VPWR sky130_fd_sc_hd__fill_2
XFILLER_0_36_37 VPWR VGND VPWR VGND sky130_ef_sc_hd__decap_12
XFILLER_0_36_15 VGND VGND VPWR VPWR sky130_fd_sc_hd__decap_3
X_0972_ _0424_ VGND VGND VPWR VPWR _0425_ sky130_fd_sc_hd__clkbuf_4
Xu_ro_bank.g_ro\[7\].u_ro.g_stg\[13\].u_inv_u_cell u_ro_bank.g_ro\[7\].u_ro.n\[12\]
+ VGND VGND VPWR VPWR u_ro_bank.g_ro\[7\].u_ro.n\[13\] sky130_fd_sc_hd__inv_1
XFILLER_0_26_81 VGND VGND VPWR VPWR sky130_fd_sc_hd__decap_3
XFILLER_0_9_177 VGND VGND VPWR VPWR sky130_fd_sc_hd__decap_8
XFILLER_0_13_172 VGND VGND VPWR VPWR sky130_fd_sc_hd__decap_6
XPHY_95 VGND VGND VPWR VPWR sky130_fd_sc_hd__decap_3
XPHY_84 VGND VGND VPWR VPWR sky130_fd_sc_hd__decap_3
XPHY_73 VGND VGND VPWR VPWR sky130_fd_sc_hd__decap_3
XPHY_62 VGND VGND VPWR VPWR sky130_fd_sc_hd__decap_3
XPHY_40 VGND VGND VPWR VPWR sky130_fd_sc_hd__decap_3
XPHY_51 VGND VGND VPWR VPWR sky130_fd_sc_hd__decap_3
XFILLER_0_28_209 VGND VGND VPWR VPWR sky130_fd_sc_hd__decap_6
X_1171_ div\[20\] _0571_ _0521_ VGND VGND VPWR VPWR _0574_ sky130_fd_sc_hd__a21boi_1
X_1240_ clknet_4_1_0_clk _0024_ VGND VGND VPWR VPWR warm\[2\] sky130_fd_sc_hd__dfxtp_1
XFILLER_0_2_27 VGND VGND VPWR VPWR sky130_fd_sc_hd__fill_1
X_0955_ _0378_ _0380_ _0384_ VGND VGND VPWR VPWR _0412_ sky130_fd_sc_hd__nand3_1
XFILLER_0_42_245 VGND VGND VPWR VPWR sky130_fd_sc_hd__decap_6
X_0886_ u_apt.cnt\[1\] u_apt.cnt\[0\] VGND VGND VPWR VPWR _0358_ sky130_fd_sc_hd__or2_1
XFILLER_0_12_72 VPWR VGND VPWR VGND sky130_ef_sc_hd__decap_12
XFILLER_0_42_289 VGND VGND VPWR VPWR sky130_fd_sc_hd__fill_2
XFILLER_0_10_175 VGND VGND VPWR VPWR sky130_fd_sc_hd__fill_1
XFILLER_0_10_186 VGND VGND VPWR VPWR sky130_fd_sc_hd__decap_4
XFILLER_0_33_289 VGND VGND VPWR VPWR sky130_fd_sc_hd__fill_2
XFILLER_0_33_278 VGND VGND VPWR VPWR sky130_fd_sc_hd__fill_2
XFILLER_0_5_191 VPWR VGND VPWR VGND sky130_ef_sc_hd__decap_12
XFILLER_0_33_27 VGND VGND VPWR VPWR sky130_fd_sc_hd__fill_2
XFILLER_0_17_39 VPWR VGND VPWR VGND sky130_ef_sc_hd__decap_12
X_0740_ warm\[4\] _0247_ VGND VGND VPWR VPWR _0252_ sky130_fd_sc_hd__or2_1
XFILLER_0_24_212 VGND VGND VPWR VPWR sky130_fd_sc_hd__fill_1
XFILLER_0_3_139 VGND VGND VPWR VPWR sky130_fd_sc_hd__fill_1
X_0671_ _0157_ bit_idx\[0\] bit_idx\[2\] VGND VGND VPWR VPWR _0197_ sky130_fd_sc_hd__or3b_1
XFILLER_0_24_289 VGND VGND VPWR VPWR sky130_fd_sc_hd__fill_2
X_1154_ _0561_ VGND VGND VPWR VPWR _0130_ sky130_fd_sc_hd__clkbuf_1
X_1223_ clknet_4_14_0_clk _0008_ VGND VGND VPWR VPWR byte_reg\[0\] sky130_fd_sc_hd__dfxtp_1
X_1085_ u_uart.clk_cnt\[13\] _0437_ _0504_ _0469_ u_uart.clk_cnt\[14\] VGND VGND VPWR
+ VPWR _0511_ sky130_fd_sc_hd__a32o_1
X_0938_ _0398_ _0396_ VGND VGND VPWR VPWR _0399_ sky130_fd_sc_hd__nor2_2
Xu_ro_bank.g_ro\[7\].u_ro.g_stg\[9\].u_inv_u_cell u_ro_bank.g_ro\[7\].u_ro.n\[8\]
+ VGND VGND VPWR VPWR u_ro_bank.g_ro\[7\].u_ro.n\[9\] sky130_fd_sc_hd__inv_1
X_0869_ net9 _0341_ _0206_ VGND VGND VPWR VPWR _0344_ sky130_fd_sc_hd__o21ai_1
XFILLER_0_15_223 VGND VGND VPWR VPWR sky130_fd_sc_hd__fill_1
XFILLER_0_15_289 VGND VGND VPWR VPWR sky130_fd_sc_hd__fill_2
XFILLER_0_3_81 VPWR VGND VPWR VGND sky130_ef_sc_hd__decap_12
XFILLER_0_0_109 VGND VGND VPWR VPWR sky130_fd_sc_hd__decap_3
XFILLER_0_44_15 VPWR VGND VPWR VGND sky130_ef_sc_hd__decap_12
XFILLER_0_28_49 VPWR VGND VPWR VGND sky130_ef_sc_hd__decap_12
X_0723_ _0235_ VGND VGND VPWR VPWR _0239_ sky130_fd_sc_hd__buf_4
X_0654_ _0177_ _0176_ VGND VGND VPWR VPWR _0183_ sky130_fd_sc_hd__nor2_1
X_1206_ _0524_ _0597_ _0599_ VGND VGND VPWR VPWR _0600_ sky130_fd_sc_hd__and3_1
X_1137_ _0548_ _0524_ _0549_ VGND VGND VPWR VPWR _0550_ sky130_fd_sc_hd__and3b_1
X_1068_ _0497_ VGND VGND VPWR VPWR _0498_ sky130_fd_sc_hd__inv_2
XFILLER_0_39_37 VGND VGND VPWR VPWR sky130_fd_sc_hd__decap_3
XTAP_207 VGND VPWR sky130_fd_sc_hd__tapvpwrvgnd_1
XTAP_218 VGND VPWR sky130_fd_sc_hd__tapvpwrvgnd_1
XTAP_229 VGND VPWR sky130_fd_sc_hd__tapvpwrvgnd_1
Xhold3 u_apt.idx\[15\] VGND VGND VPWR VPWR net9 sky130_fd_sc_hd__dlygate4sd3_1
XFILLER_0_44_137 VGND VGND VPWR VPWR sky130_fd_sc_hd__decap_3
X_0706_ _0222_ _0223_ _0224_ _0225_ VGND VGND VPWR VPWR _0226_ sky130_fd_sc_hd__or4_1
Xclkbuf_4_4_0_clk clknet_0_clk VGND VGND VPWR VPWR clknet_4_4_0_clk sky130_fd_sc_hd__clkbuf_8
XFILLER_0_4_289 VGND VGND VPWR VPWR sky130_fd_sc_hd__fill_2
XFILLER_0_4_212 VGND VGND VPWR VPWR sky130_fd_sc_hd__fill_2
XFILLER_0_20_61 VPWR VGND VPWR VGND sky130_ef_sc_hd__decap_12
XFILLER_0_31_3 VPWR VGND VPWR VGND sky130_ef_sc_hd__decap_12
X_0637_ net34 _0162_ _0170_ _0166_ VGND VGND VPWR VPWR _0004_ sky130_fd_sc_hd__o211a_1
XFILLER_0_43_181 VPWR VGND VPWR VGND sky130_ef_sc_hd__decap_12
XFILLER_0_25_39 VGND VGND VPWR VPWR sky130_fd_sc_hd__fill_1
XFILLER_0_26_137 VGND VGND VPWR VPWR sky130_fd_sc_hd__decap_3
XFILLER_0_41_129 VGND VGND VPWR VPWR sky130_fd_sc_hd__fill_1
XFILLER_0_41_107 VGND VGND VPWR VPWR sky130_fd_sc_hd__decap_4
XFILLER_0_1_237 VPWR VGND VPWR VGND sky130_ef_sc_hd__decap_12
Xu_ro_bank.g_ro\[6\].u_ro.g_stg\[5\].u_inv_u_cell u_ro_bank.g_ro\[6\].u_ro.n\[4\]
+ VGND VGND VPWR VPWR u_ro_bank.g_ro\[6\].u_ro.n\[5\] sky130_fd_sc_hd__inv_1
XFILLER_0_15_72 VGND VGND VPWR VPWR sky130_fd_sc_hd__fill_1
XFILLER_0_0_281 VGND VGND VPWR VPWR sky130_fd_sc_hd__decap_8
Xu_ro_bank.g_ro\[6\].u_ro.g_stg\[10\].u_inv_u_cell u_ro_bank.g_ro\[6\].u_ro.n\[9\]
+ VGND VGND VPWR VPWR u_ro_bank.g_ro\[6\].u_ro.n\[10\] sky130_fd_sc_hd__inv_1
XFILLER_0_16_181 VGND VGND VPWR VPWR sky130_fd_sc_hd__decap_3
XFILLER_0_23_129 VPWR VGND VPWR VGND sky130_ef_sc_hd__decap_12
XFILLER_0_36_49 VPWR VGND VPWR VGND sky130_ef_sc_hd__decap_12
XFILLER_0_39_251 VGND VGND VPWR VPWR sky130_fd_sc_hd__fill_1
X_0971_ u_uart.busy VGND VGND VPWR VPWR _0424_ sky130_fd_sc_hd__clkbuf_4
XFILLER_0_14_107 VGND VGND VPWR VPWR sky130_fd_sc_hd__fill_2
XFILLER_0_9_156 VGND VGND VPWR VPWR sky130_fd_sc_hd__decap_4
XFILLER_0_26_71 VGND VGND VPWR VPWR sky130_fd_sc_hd__fill_2
XFILLER_0_13_140 VGND VGND VPWR VPWR sky130_fd_sc_hd__decap_3
XPHY_30 VGND VGND VPWR VPWR sky130_fd_sc_hd__decap_3
XPHY_96 VGND VGND VPWR VPWR sky130_fd_sc_hd__decap_3
XPHY_85 VGND VGND VPWR VPWR sky130_fd_sc_hd__decap_3
XPHY_74 VGND VGND VPWR VPWR sky130_fd_sc_hd__decap_3
XFILLER_0_36_221 VPWR VGND VPWR VGND sky130_ef_sc_hd__decap_12
XPHY_63 VGND VGND VPWR VPWR sky130_fd_sc_hd__decap_3
XPHY_41 VGND VGND VPWR VPWR sky130_fd_sc_hd__decap_3
XFILLER_0_22_29 VPWR VGND VPWR VGND sky130_ef_sc_hd__decap_12
XPHY_52 VGND VGND VPWR VPWR sky130_fd_sc_hd__decap_3
XFILLER_0_47_15 VPWR VGND VPWR VGND sky130_ef_sc_hd__decap_12
X_1170_ _0573_ VGND VGND VPWR VPWR _0134_ sky130_fd_sc_hd__clkbuf_1
X_0954_ u_apt.cnt\[8\] VGND VGND VPWR VPWR _0411_ sky130_fd_sc_hd__inv_2
X_0885_ u_apt.cnt\[1\] u_apt.cnt\[0\] VGND VGND VPWR VPWR _0357_ sky130_fd_sc_hd__nand2_1
X_1299_ clknet_4_12_0_clk _0081_ VGND VGND VPWR VPWR u_apt.fail sky130_fd_sc_hd__dfxtp_1
XFILLER_0_18_221 VGND VGND VPWR VPWR sky130_fd_sc_hd__decap_4
XFILLER_0_18_287 VGND VGND VPWR VPWR sky130_fd_sc_hd__decap_4
X_0670_ _0196_ VGND VGND VPWR VPWR _0011_ sky130_fd_sc_hd__clkbuf_1
X_1153_ _0559_ _0535_ _0560_ VGND VGND VPWR VPWR _0561_ sky130_fd_sc_hd__and3b_1
Xu_ro_bank.g_ro\[5\].u_ro.g_stg\[1\].u_inv_u_cell u_ro_bank.g_ro\[5\].u_ro.n\[0\]
+ VGND VGND VPWR VPWR u_ro_bank.g_ro\[5\].u_ro.n\[1\] sky130_fd_sc_hd__inv_1
X_1222_ clknet_4_9_0_clk _0007_ VGND VGND VPWR VPWR u_uart.tx_data\[7\] sky130_fd_sc_hd__dfxtp_1
X_1084_ _0236_ _0510_ VGND VGND VPWR VPWR _0111_ sky130_fd_sc_hd__nor2_1
X_0799_ _0271_ _0276_ VGND VGND VPWR VPWR _0293_ sky130_fd_sc_hd__and2b_1
X_0937_ net41 VGND VGND VPWR VPWR _0398_ sky130_fd_sc_hd__inv_2
X_0868_ _0343_ VGND VGND VPWR VPWR _0062_ sky130_fd_sc_hd__clkbuf_1
XFILLER_0_3_93 VPWR VGND VPWR VGND sky130_ef_sc_hd__decap_12
XFILLER_0_44_27 VGND VGND VPWR VPWR sky130_fd_sc_hd__fill_1
X_0722_ _0236_ _0231_ VGND VGND VPWR VPWR _0021_ sky130_fd_sc_hd__nor2_1
X_0653_ _0182_ VGND VGND VPWR VPWR _0008_ sky130_fd_sc_hd__clkbuf_1
XFILLER_0_47_113 VGND VGND VPWR VPWR sky130_fd_sc_hd__fill_1
XFILLER_0_47_102 VGND VGND VPWR VPWR sky130_fd_sc_hd__decap_3
X_1205_ _0593_ _0598_ VGND VGND VPWR VPWR _0599_ sky130_fd_sc_hd__nand2_1
X_1067_ u_uart.clk_cnt\[10\] _0496_ VGND VGND VPWR VPWR _0497_ sky130_fd_sc_hd__and2_1
XFILLER_0_18_83 VGND VGND VPWR VPWR sky130_fd_sc_hd__fill_1
X_1136_ div\[7\] _0547_ _0537_ div\[10\] VGND VGND VPWR VPWR _0549_ sky130_fd_sc_hd__a31o_1
XFILLER_0_7_265 VGND VGND VPWR VPWR sky130_fd_sc_hd__fill_2
XFILLER_0_30_29 VGND VGND VPWR VPWR sky130_fd_sc_hd__decap_4
Xhold4 u_apt.fail VGND VGND VPWR VPWR net10 sky130_fd_sc_hd__dlygate4sd3_1
XTAP_208 VGND VPWR sky130_fd_sc_hd__tapvpwrvgnd_1
XTAP_219 VGND VPWR sky130_fd_sc_hd__tapvpwrvgnd_1
XFILLER_0_29_113 VGND VGND VPWR VPWR sky130_fd_sc_hd__fill_2
X_0705_ div\[13\] div\[12\] div\[15\] div\[14\] VGND VGND VPWR VPWR _0225_ sky130_fd_sc_hd__or4_1
XFILLER_0_20_73 VGND VGND VPWR VPWR sky130_fd_sc_hd__fill_1
X_0636_ byte_reg\[4\] _0163_ VGND VGND VPWR VPWR _0170_ sky130_fd_sc_hd__or2_1
Xu_ro_bank.g_ro\[1\].u_ro.g_stg\[4\].u_inv_u_cell u_ro_bank.g_ro\[1\].u_ro.n\[3\]
+ VGND VGND VPWR VPWR u_ro_bank.g_ro\[1\].u_ro.n\[4\] sky130_fd_sc_hd__inv_1
XFILLER_0_24_3 VPWR VGND VPWR VGND sky130_ef_sc_hd__decap_12
X_1119_ _0536_ VGND VGND VPWR VPWR _0120_ sky130_fd_sc_hd__clkbuf_1
XFILLER_0_43_193 VPWR VGND VPWR VGND sky130_ef_sc_hd__decap_12
XFILLER_0_28_190 VGND VGND VPWR VPWR sky130_fd_sc_hd__decap_6
XFILLER_0_5_17 VPWR VGND VPWR VGND sky130_ef_sc_hd__decap_12
XFILLER_0_1_249 VPWR VGND VPWR VGND sky130_ef_sc_hd__decap_12
XFILLER_0_40_141 VGND VGND VPWR VPWR sky130_fd_sc_hd__decap_4
X_0619_ bit_idx\[1\] VGND VGND VPWR VPWR _0157_ sky130_fd_sc_hd__buf_2
XFILLER_0_48_230 VPWR VGND VPWR VGND sky130_ef_sc_hd__decap_12
XFILLER_0_16_171 VGND VGND VPWR VPWR sky130_fd_sc_hd__decap_3
Xclkbuf_4_3_0_clk clknet_0_clk VGND VGND VPWR VPWR clknet_4_3_0_clk sky130_fd_sc_hd__clkbuf_8
X_0970_ _0422_ _0423_ _0239_ VGND VGND VPWR VPWR _0084_ sky130_fd_sc_hd__a21oi_1
XFILLER_0_22_141 VGND VGND VPWR VPWR sky130_fd_sc_hd__decap_6
XPHY_64 VGND VGND VPWR VPWR sky130_fd_sc_hd__decap_3
XPHY_20 VGND VGND VPWR VPWR sky130_fd_sc_hd__decap_3
XPHY_31 VGND VGND VPWR VPWR sky130_fd_sc_hd__decap_3
XPHY_42 VGND VGND VPWR VPWR sky130_fd_sc_hd__decap_3
XPHY_53 VGND VGND VPWR VPWR sky130_fd_sc_hd__decap_3
XPHY_97 VGND VGND VPWR VPWR sky130_fd_sc_hd__decap_3
XPHY_86 VGND VGND VPWR VPWR sky130_fd_sc_hd__decap_3
XPHY_75 VGND VGND VPWR VPWR sky130_fd_sc_hd__decap_3
XFILLER_0_36_288 VGND VGND VPWR VPWR sky130_fd_sc_hd__decap_3
XFILLER_0_36_233 VGND VGND VPWR VPWR sky130_fd_sc_hd__decap_6
XFILLER_0_47_27 VPWR VGND VPWR VGND sky130_ef_sc_hd__decap_12
XFILLER_0_2_29 VPWR VGND VPWR VGND sky130_ef_sc_hd__decap_12
X_0953_ _0359_ _0362_ _0382_ u_apt.cnt\[8\] VGND VGND VPWR VPWR _0410_ sky130_fd_sc_hd__o22a_1
X_0884_ _0351_ VGND VGND VPWR VPWR _0356_ sky130_fd_sc_hd__buf_2
XFILLER_0_6_138 VGND VGND VPWR VPWR sky130_fd_sc_hd__fill_2
XFILLER_0_12_85 VPWR VGND VPWR VGND sky130_ef_sc_hd__decap_12
X_1298_ clknet_4_14_0_clk _0080_ VGND VGND VPWR VPWR u_apt.cnt\[15\] sky130_fd_sc_hd__dfxtp_1
XFILLER_0_33_225 VGND VGND VPWR VPWR sky130_fd_sc_hd__fill_2
X_1221_ clknet_4_11_0_clk net31 VGND VGND VPWR VPWR u_uart.tx_data\[6\] sky130_fd_sc_hd__dfxtp_1
X_1152_ div\[14\] _0555_ div\[15\] VGND VGND VPWR VPWR _0560_ sky130_fd_sc_hd__a21o_1
X_1083_ net94 _0506_ _0509_ VGND VGND VPWR VPWR _0510_ sky130_fd_sc_hd__a21oi_1
X_0936_ net67 _0393_ _0397_ _0372_ VGND VGND VPWR VPWR _0076_ sky130_fd_sc_hd__o211a_1
XFILLER_0_15_225 VPWR VGND VPWR VGND sky130_ef_sc_hd__decap_12
XFILLER_0_23_51 VGND VGND VPWR VPWR sky130_fd_sc_hd__fill_2
X_0798_ _0291_ _0292_ _0166_ VGND VGND VPWR VPWR _0043_ sky130_fd_sc_hd__o21a_1
XFILLER_0_2_141 VGND VGND VPWR VPWR sky130_fd_sc_hd__fill_2
X_0867_ _0341_ _0251_ _0342_ VGND VGND VPWR VPWR _0343_ sky130_fd_sc_hd__and3b_1
XFILLER_0_48_81 VGND VGND VPWR VPWR sky130_fd_sc_hd__decap_3
XFILLER_0_3_50 VGND VGND VPWR VPWR sky130_fd_sc_hd__decap_6
XFILLER_0_14_280 VGND VGND VPWR VPWR sky130_fd_sc_hd__fill_1
X_0721_ _0238_ VGND VGND VPWR VPWR _0020_ sky130_fd_sc_hd__clkbuf_1
XFILLER_0_12_206 VGND VGND VPWR VPWR sky130_fd_sc_hd__fill_1
X_0652_ _0175_ _0181_ VGND VGND VPWR VPWR _0182_ sky130_fd_sc_hd__and2_1
X_1204_ div\[29\] div\[28\] VGND VGND VPWR VPWR _0598_ sky130_fd_sc_hd__and2_1
XFILLER_0_34_94 VGND VGND VPWR VPWR sky130_fd_sc_hd__decap_8
X_1135_ div\[7\] div\[10\] _0547_ _0537_ VGND VGND VPWR VPWR _0548_ sky130_fd_sc_hd__and4_1
X_1066_ u_uart.clk_cnt\[9\] u_uart.clk_cnt\[8\] u_uart.clk_cnt\[7\] _0484_ VGND VGND
+ VPWR VPWR _0496_ sky130_fd_sc_hd__and4_1
XFILLER_0_47_169 VGND VGND VPWR VPWR sky130_fd_sc_hd__fill_2
X_0919_ u_apt.cnt\[7\] _0356_ _0374_ _0384_ VGND VGND VPWR VPWR _0385_ sky130_fd_sc_hd__o2bb2a_1
XFILLER_0_7_233 VGND VGND VPWR VPWR sky130_fd_sc_hd__decap_8
Xu_ro_bank.g_ro\[7\].u_ro.g_stg\[5\].u_inv_u_cell u_ro_bank.g_ro\[7\].u_ro.n\[4\]
+ VGND VGND VPWR VPWR u_ro_bank.g_ro\[7\].u_ro.n\[5\] sky130_fd_sc_hd__inv_1
XFILLER_0_39_28 VGND VGND VPWR VPWR sky130_fd_sc_hd__fill_2
Xhold5 u_rct.fail VGND VGND VPWR VPWR net11 sky130_fd_sc_hd__dlygate4sd3_1
XTAP_209 VGND VPWR sky130_fd_sc_hd__tapvpwrvgnd_1
XFILLER_0_29_103 VGND VGND VPWR VPWR sky130_fd_sc_hd__decap_8
X_0704_ div\[17\] div\[16\] div\[19\] div\[18\] VGND VGND VPWR VPWR _0224_ sky130_fd_sc_hd__or4_1
X_0635_ net32 _0162_ _0169_ _0166_ VGND VGND VPWR VPWR _0003_ sky130_fd_sc_hd__o211a_1
XFILLER_0_17_3 VPWR VGND VPWR VGND sky130_ef_sc_hd__decap_12
X_1118_ _0533_ _0534_ _0535_ VGND VGND VPWR VPWR _0536_ sky130_fd_sc_hd__and3b_1
X_1049_ _0434_ _0480_ _0483_ _0239_ VGND VGND VPWR VPWR _0103_ sky130_fd_sc_hd__a211oi_1
Xu_sampler__1_ clknet_4_0_0_clk net7 VGND VGND VPWR VPWR u_apt.b sky130_fd_sc_hd__dfxtp_2
XFILLER_0_5_29 VPWR VGND VPWR VGND sky130_ef_sc_hd__decap_12
XFILLER_0_31_84 VGND VGND VPWR VPWR sky130_fd_sc_hd__fill_2
XFILLER_0_25_150 VGND VGND VPWR VPWR sky130_fd_sc_hd__decap_3
XFILLER_0_25_161 VGND VGND VPWR VPWR sky130_fd_sc_hd__decap_4
XFILLER_0_40_197 VGND VGND VPWR VPWR sky130_fd_sc_hd__decap_3
X_0618_ bit_idx\[0\] _0155_ VGND VGND VPWR VPWR _0156_ sky130_fd_sc_hd__nand2_1
XFILLER_0_48_253 VPWR VGND VPWR VGND sky130_ef_sc_hd__decap_12
XFILLER_0_48_242 VGND VGND VPWR VPWR sky130_fd_sc_hd__decap_8
XFILLER_0_23_109 VGND VGND VPWR VPWR sky130_fd_sc_hd__decap_3
XFILLER_0_6_3 VGND VGND VPWR VPWR sky130_fd_sc_hd__decap_8
XFILLER_0_36_29 VGND VGND VPWR VPWR sky130_fd_sc_hd__fill_2
Xu_ro_bank.g_ro\[3\].u_ro.g_stg\[8\].u_inv_u_cell u_ro_bank.g_ro\[3\].u_ro.n\[7\]
+ VGND VGND VPWR VPWR u_ro_bank.g_ro\[3\].u_ro.n\[8\] sky130_fd_sc_hd__inv_1
XFILLER_0_22_153 VGND VGND VPWR VPWR sky130_fd_sc_hd__fill_2
XFILLER_0_22_164 VPWR VGND VPWR VGND sky130_ef_sc_hd__decap_12
XFILLER_0_22_197 VGND VGND VPWR VPWR sky130_fd_sc_hd__decap_4
XFILLER_0_26_40 VGND VGND VPWR VPWR sky130_fd_sc_hd__decap_6
XFILLER_0_45_278 VGND VGND VPWR VPWR sky130_fd_sc_hd__fill_2
XFILLER_0_42_72 VGND VGND VPWR VPWR sky130_fd_sc_hd__fill_1
XFILLER_0_9_136 VGND VGND VPWR VPWR sky130_fd_sc_hd__decap_4
XFILLER_0_45_289 VGND VGND VPWR VPWR sky130_fd_sc_hd__fill_2
Xu_ro_bank.g_ro\[6\].u_ro.g_stg\[1\].u_inv_u_cell u_ro_bank.g_ro\[6\].u_ro.n\[0\]
+ VGND VGND VPWR VPWR u_ro_bank.g_ro\[6\].u_ro.n\[1\] sky130_fd_sc_hd__inv_1
XPHY_87 VGND VGND VPWR VPWR sky130_fd_sc_hd__decap_3
XPHY_76 VGND VGND VPWR VPWR sky130_fd_sc_hd__decap_3
XPHY_65 VGND VGND VPWR VPWR sky130_fd_sc_hd__decap_3
XPHY_10 VGND VGND VPWR VPWR sky130_fd_sc_hd__decap_3
XPHY_21 VGND VGND VPWR VPWR sky130_fd_sc_hd__decap_3
XPHY_32 VGND VGND VPWR VPWR sky130_fd_sc_hd__decap_3
XPHY_43 VGND VGND VPWR VPWR sky130_fd_sc_hd__decap_3
XPHY_54 VGND VGND VPWR VPWR sky130_fd_sc_hd__decap_3
XFILLER_0_47_39 VGND VGND VPWR VPWR sky130_fd_sc_hd__decap_6
X_0952_ _0409_ VGND VGND VPWR VPWR _0080_ sky130_fd_sc_hd__clkbuf_1
XFILLER_0_27_223 VGND VGND VPWR VPWR sky130_fd_sc_hd__fill_1
X_0883_ net86 _0352_ _0355_ _0172_ VGND VGND VPWR VPWR _0065_ sky130_fd_sc_hd__o211a_1
XFILLER_0_12_97 VGND VGND VPWR VPWR sky130_fd_sc_hd__decap_4
X_1297_ clknet_4_14_0_clk _0079_ VGND VGND VPWR VPWR u_apt.cnt\[14\] sky130_fd_sc_hd__dfxtp_1
Xclkbuf_4_2_0_clk clknet_0_clk VGND VGND VPWR VPWR clknet_4_2_0_clk sky130_fd_sc_hd__clkbuf_8
XFILLER_0_41_281 VGND VGND VPWR VPWR sky130_fd_sc_hd__decap_8
X_1151_ div\[15\] div\[14\] _0555_ VGND VGND VPWR VPWR _0559_ sky130_fd_sc_hd__and3_1
X_1220_ clknet_4_11_0_clk net25 VGND VGND VPWR VPWR u_uart.tx_data\[5\] sky130_fd_sc_hd__dfxtp_1
X_1082_ u_uart.clk_cnt\[13\] _0437_ _0504_ VGND VGND VPWR VPWR _0509_ sky130_fd_sc_hd__and3b_1
X_0935_ u_apt.cnt\[11\] _0356_ _0354_ _0396_ VGND VGND VPWR VPWR _0397_ sky130_fd_sc_hd__a22o_1
X_0866_ u_apt.idx\[14\] _0338_ VGND VGND VPWR VPWR _0342_ sky130_fd_sc_hd__or2_1
XFILLER_0_15_215 VGND VGND VPWR VPWR sky130_fd_sc_hd__decap_8
XFILLER_0_15_237 VPWR VGND VPWR VGND sky130_ef_sc_hd__decap_12
X_0797_ u_rct.cnt\[5\] _0270_ _0279_ VGND VGND VPWR VPWR _0292_ sky130_fd_sc_hd__and3b_1
XFILLER_0_2_197 VGND VGND VPWR VPWR sky130_fd_sc_hd__fill_1
XFILLER_0_23_281 VGND VGND VPWR VPWR sky130_fd_sc_hd__decap_8
XFILLER_0_47_3 VPWR VGND VPWR VGND sky130_ef_sc_hd__decap_12
X_1349_ clknet_4_5_0_clk _0131_ VGND VGND VPWR VPWR div\[16\] sky130_fd_sc_hd__dfxtp_1
XFILLER_0_3_40 VGND VGND VPWR VPWR sky130_fd_sc_hd__fill_1
XFILLER_0_14_270 VGND VGND VPWR VPWR sky130_fd_sc_hd__fill_1
Xu_ro_bank.g_ro\[2\].u_ro.g_stg\[4\].u_inv_u_cell u_ro_bank.g_ro\[2\].u_ro.n\[3\]
+ VGND VGND VPWR VPWR u_ro_bank.g_ro\[2\].u_ro.n\[4\] sky130_fd_sc_hd__inv_1
XFILLER_0_8_29 VPWR VGND VPWR VGND sky130_ef_sc_hd__decap_12
X_0720_ u_apt.b _0237_ VGND VGND VPWR VPWR _0238_ sky130_fd_sc_hd__and2_1
XFILLER_0_20_251 VGND VGND VPWR VPWR sky130_fd_sc_hd__fill_1
X_0651_ byte_reg\[0\] _0176_ _0178_ _0180_ VGND VGND VPWR VPWR _0181_ sky130_fd_sc_hd__a22o_1
X_1203_ div\[28\] _0593_ div\[29\] VGND VGND VPWR VPWR _0597_ sky130_fd_sc_hd__a21o_1
XFILLER_0_18_41 VGND VGND VPWR VPWR sky130_fd_sc_hd__decap_6
XFILLER_0_18_85 VPWR VGND VPWR VGND sky130_ef_sc_hd__decap_12
X_1134_ _0545_ VGND VGND VPWR VPWR _0547_ sky130_fd_sc_hd__inv_2
XFILLER_0_34_73 VGND VGND VPWR VPWR sky130_fd_sc_hd__decap_3
XFILLER_0_34_51 VGND VGND VPWR VPWR sky130_fd_sc_hd__fill_1
X_1065_ _0495_ VGND VGND VPWR VPWR _0107_ sky130_fd_sc_hd__clkbuf_1
X_0918_ _0382_ _0383_ VGND VGND VPWR VPWR _0384_ sky130_fd_sc_hd__or2b_1
XFILLER_0_7_289 VGND VGND VPWR VPWR sky130_fd_sc_hd__fill_2
X_0849_ u_apt.idx\[10\] u_apt.idx\[7\] u_apt.idx\[6\] _0316_ VGND VGND VPWR VPWR _0329_
+ sky130_fd_sc_hd__nand4_1
Xhold6 net5 VGND VGND VPWR VPWR net12 sky130_fd_sc_hd__dlygate4sd3_1
XFILLER_0_44_129 VGND VGND VPWR VPWR sky130_fd_sc_hd__decap_8
X_0703_ div\[7\] div\[6\] div\[9\] div\[8\] VGND VGND VPWR VPWR _0223_ sky130_fd_sc_hd__nand4_1
X_0634_ byte_reg\[3\] _0163_ VGND VGND VPWR VPWR _0169_ sky130_fd_sc_hd__or2_1
X_1117_ _0520_ VGND VGND VPWR VPWR _0535_ sky130_fd_sc_hd__buf_2
XFILLER_0_0_41 VPWR VGND VPWR VGND sky130_ef_sc_hd__decap_12
XFILLER_0_0_85 VPWR VGND VPWR VGND sky130_ef_sc_hd__decap_12
X_1048_ u_uart.clk_cnt\[5\] _0457_ _0473_ _0482_ VGND VGND VPWR VPWR _0483_ sky130_fd_sc_hd__o2bb2a_1
XFILLER_0_28_170 VGND VGND VPWR VPWR sky130_fd_sc_hd__fill_1
XFILLER_0_3_281 VGND VGND VPWR VPWR sky130_fd_sc_hd__decap_8
Xu_sampler__0_ clknet_4_0_0_clk u_ro_bank.x VGND VGND VPWR VPWR hold1/A sky130_fd_sc_hd__dfxtp_1
XFILLER_0_34_173 VPWR VGND VPWR VGND sky130_ef_sc_hd__decap_12
XFILLER_0_15_42 VGND VGND VPWR VPWR sky130_fd_sc_hd__fill_2
XFILLER_0_17_129 VPWR VGND VPWR VGND sky130_ef_sc_hd__decap_12
X_0617_ _0154_ net4 VGND VGND VPWR VPWR _0155_ sky130_fd_sc_hd__nor2_2
XFILLER_0_48_221 VGND VGND VPWR VPWR sky130_fd_sc_hd__decap_3
XFILLER_0_48_265 VPWR VGND VPWR VGND sky130_ef_sc_hd__decap_12
XFILLER_0_31_132 VPWR VGND VPWR VGND sky130_ef_sc_hd__decap_12
XFILLER_0_39_243 VGND VGND VPWR VPWR sky130_fd_sc_hd__fill_1
XFILLER_0_22_176 VPWR VGND VPWR VGND sky130_ef_sc_hd__decap_12
XFILLER_0_26_63 VGND VGND VPWR VPWR sky130_fd_sc_hd__fill_1
XFILLER_0_26_85 VGND VGND VPWR VPWR sky130_fd_sc_hd__decap_4
XFILLER_0_45_246 VPWR VGND VPWR VGND sky130_ef_sc_hd__decap_12
XFILLER_0_9_148 VGND VGND VPWR VPWR sky130_fd_sc_hd__decap_3
XFILLER_0_13_154 VPWR VGND VPWR VGND sky130_ef_sc_hd__decap_12
XFILLER_0_6_95 VGND VGND VPWR VPWR sky130_fd_sc_hd__fill_1
XPHY_88 VGND VGND VPWR VPWR sky130_fd_sc_hd__decap_3
XPHY_77 VGND VGND VPWR VPWR sky130_fd_sc_hd__decap_3
XPHY_66 VGND VGND VPWR VPWR sky130_fd_sc_hd__decap_3
XPHY_11 VGND VGND VPWR VPWR sky130_fd_sc_hd__decap_3
XPHY_22 VGND VGND VPWR VPWR sky130_fd_sc_hd__decap_3
XPHY_33 VGND VGND VPWR VPWR sky130_fd_sc_hd__decap_3
XPHY_44 VGND VGND VPWR VPWR sky130_fd_sc_hd__decap_3
XPHY_55 VGND VGND VPWR VPWR sky130_fd_sc_hd__decap_3
X_0882_ net86 _0354_ VGND VGND VPWR VPWR _0355_ sky130_fd_sc_hd__nand2_1
X_0951_ _0175_ _0408_ VGND VGND VPWR VPWR _0409_ sky130_fd_sc_hd__and2_1
XFILLER_0_27_213 VGND VGND VPWR VPWR sky130_fd_sc_hd__fill_1
X_1296_ clknet_4_15_0_clk _0078_ VGND VGND VPWR VPWR u_apt.cnt\[13\] sky130_fd_sc_hd__dfxtp_1
Xu_ro_bank.g_ro\[1\].u_ro.u_nand_u_cell u_ro_bank.g_ro\[1\].u_ro.n\[4\] u_ro_bank.en
+ VGND VGND VPWR VPWR u_ro_bank.g_ro\[1\].u_ro.n\[0\] sky130_fd_sc_hd__nand2_1
XTAP_190 VGND VPWR sky130_fd_sc_hd__tapvpwrvgnd_1
XFILLER_0_24_205 VGND VGND VPWR VPWR sky130_fd_sc_hd__fill_2
XFILLER_0_24_249 VGND VGND VPWR VPWR sky130_fd_sc_hd__decap_3
X_1150_ net91 _0555_ _0558_ VGND VGND VPWR VPWR _0129_ sky130_fd_sc_hd__o21a_1
X_1081_ _0236_ _0508_ VGND VGND VPWR VPWR _0110_ sky130_fd_sc_hd__nor2_1
X_0934_ u_apt.cnt\[11\] _0393_ VGND VGND VPWR VPWR _0396_ sky130_fd_sc_hd__nand2_1
XFILLER_0_2_121 VGND VGND VPWR VPWR sky130_fd_sc_hd__decap_3
XFILLER_0_15_249 VGND VGND VPWR VPWR sky130_fd_sc_hd__fill_1
X_0865_ u_apt.idx\[14\] u_apt.idx\[13\] _0335_ VGND VGND VPWR VPWR _0341_ sky130_fd_sc_hd__and3_1
X_0796_ _0278_ _0290_ u_rct.cnt\[5\] VGND VGND VPWR VPWR _0291_ sky130_fd_sc_hd__o21a_1
Xu_ro_bank.g_ro\[3\].u_ro.u_nand_u_cell u_ro_bank.g_ro\[3\].u_ro.n\[8\] u_ro_bank.en
+ VGND VGND VPWR VPWR u_ro_bank.g_ro\[3\].u_ro.n\[0\] sky130_fd_sc_hd__nand2_1
XFILLER_0_2_154 VGND VGND VPWR VPWR sky130_fd_sc_hd__fill_1
X_1348_ clknet_4_5_0_clk _0130_ VGND VGND VPWR VPWR div\[15\] sky130_fd_sc_hd__dfxtp_1
X_1279_ clknet_4_3_0_clk _0061_ VGND VGND VPWR VPWR u_apt.idx\[13\] sky130_fd_sc_hd__dfxtp_1
Xu_ro_bank.g_ro\[5\].u_ro.u_nand_u_cell u_ro_bank.g_ro\[5\].u_ro.n\[12\] u_ro_bank.en
+ VGND VGND VPWR VPWR u_ro_bank.g_ro\[5\].u_ro.n\[0\] sky130_fd_sc_hd__nand2_1
X_0650_ u_vn.o byte_reg\[0\] _0179_ VGND VGND VPWR VPWR _0180_ sky130_fd_sc_hd__mux2_1
X_1202_ net69 _0593_ _0596_ VGND VGND VPWR VPWR _0143_ sky130_fd_sc_hd__o21a_1
X_1064_ _0237_ _0494_ VGND VGND VPWR VPWR _0495_ sky130_fd_sc_hd__and2_1
Xclkbuf_4_1_0_clk clknet_0_clk VGND VGND VPWR VPWR clknet_4_1_0_clk sky130_fd_sc_hd__clkbuf_8
XFILLER_0_18_97 VPWR VGND VPWR VGND sky130_ef_sc_hd__decap_12
X_1133_ _0545_ _0540_ _0546_ _0521_ VGND VGND VPWR VPWR _0124_ sky130_fd_sc_hd__o211a_1
XFILLER_0_34_85 VGND VGND VPWR VPWR sky130_fd_sc_hd__decap_4
X_0917_ u_apt.cnt\[6\] _0365_ _0375_ u_apt.cnt\[7\] VGND VGND VPWR VPWR _0383_ sky130_fd_sc_hd__a31o_1
X_0779_ _0272_ _0278_ VGND VGND VPWR VPWR _0279_ sky130_fd_sc_hd__nor2_1
X_0848_ u_apt.idx\[15\] u_apt.idx\[14\] u_apt.idx\[13\] u_apt.idx\[12\] VGND VGND
+ VPWR VPWR _0328_ sky130_fd_sc_hd__or4_1
Xu_ro_bank.g_ro\[7\].u_ro.u_nand_u_cell u_ro_bank.g_ro\[7\].u_ro.n\[16\] u_ro_bank.en
+ VGND VGND VPWR VPWR u_ro_bank.g_ro\[7\].u_ro.n\[0\] sky130_fd_sc_hd__nand2_1
XFILLER_0_38_127 VGND VGND VPWR VPWR sky130_fd_sc_hd__decap_8
XFILLER_0_38_116 VGND VGND VPWR VPWR sky130_fd_sc_hd__decap_4
Xhold7 warm\[8\] VGND VGND VPWR VPWR net13 sky130_fd_sc_hd__dlygate4sd3_1
XFILLER_0_37_182 VPWR VGND VPWR VGND sky130_ef_sc_hd__decap_12
X_0702_ div\[5\] div\[4\] div\[11\] div\[10\] VGND VGND VPWR VPWR _0222_ sky130_fd_sc_hd__or4b_1
XFILLER_0_4_249 VGND VGND VPWR VPWR sky130_fd_sc_hd__decap_3
X_0633_ net48 _0162_ _0168_ _0166_ VGND VGND VPWR VPWR _0002_ sky130_fd_sc_hd__o211a_1
X_1116_ div\[4\] _0531_ div\[5\] VGND VGND VPWR VPWR _0534_ sky130_fd_sc_hd__a21o_1
X_1047_ _0434_ _0480_ VGND VGND VPWR VPWR _0482_ sky130_fd_sc_hd__nor2_1
Xu_ro_bank.g_ro\[4\].u_ro.g_stg\[8\].u_inv_u_cell u_ro_bank.g_ro\[4\].u_ro.n\[7\]
+ VGND VGND VPWR VPWR u_ro_bank.g_ro\[4\].u_ro.n\[8\] sky130_fd_sc_hd__inv_1
XFILLER_0_0_53 VGND VGND VPWR VPWR sky130_fd_sc_hd__decap_3
XFILLER_0_0_97 VPWR VGND VPWR VGND sky130_ef_sc_hd__decap_12
XFILLER_0_34_141 VGND VGND VPWR VPWR sky130_fd_sc_hd__fill_1
XFILLER_0_34_130 VGND VGND VPWR VPWR sky130_fd_sc_hd__fill_2
XFILLER_0_19_193 VPWR VGND VPWR VGND sky130_ef_sc_hd__decap_12
Xu_ro_bank.g_ro\[7\].u_ro.g_stg\[1\].u_inv_u_cell u_ro_bank.g_ro\[7\].u_ro.n\[0\]
+ VGND VGND VPWR VPWR u_ro_bank.g_ro\[7\].u_ro.n\[1\] sky130_fd_sc_hd__inv_1
XFILLER_0_25_130 VPWR VGND VPWR VGND sky130_ef_sc_hd__decap_12
X_0616_ u_vn.ov VGND VGND VPWR VPWR _0154_ sky130_fd_sc_hd__inv_2
XFILLER_0_22_3 VPWR VGND VPWR VGND sky130_ef_sc_hd__decap_12
XFILLER_0_48_277 VGND VGND VPWR VPWR sky130_fd_sc_hd__decap_3
XFILLER_0_31_144 VGND VGND VPWR VPWR sky130_fd_sc_hd__decap_8
XFILLER_0_16_141 VGND VGND VPWR VPWR sky130_fd_sc_hd__decap_8
XFILLER_0_39_277 VGND VGND VPWR VPWR sky130_fd_sc_hd__decap_3
XFILLER_0_22_188 VGND VGND VPWR VPWR sky130_fd_sc_hd__decap_8
XFILLER_0_42_52 VPWR VGND VPWR VGND sky130_ef_sc_hd__decap_12
XFILLER_0_42_41 VGND VGND VPWR VPWR sky130_fd_sc_hd__fill_1
XFILLER_0_45_258 VPWR VGND VPWR VGND sky130_ef_sc_hd__decap_12
XFILLER_0_42_96 VPWR VGND VPWR VGND sky130_ef_sc_hd__decap_12
XFILLER_0_42_85 VGND VGND VPWR VPWR sky130_fd_sc_hd__decap_6
XTAP_350 VGND VPWR sky130_fd_sc_hd__tapvpwrvgnd_1
XFILLER_0_13_166 VGND VGND VPWR VPWR sky130_fd_sc_hd__fill_2
XFILLER_0_13_188 VPWR VGND VPWR VGND sky130_ef_sc_hd__decap_12
XPHY_12 VGND VGND VPWR VPWR sky130_fd_sc_hd__decap_3
XPHY_89 VGND VGND VPWR VPWR sky130_fd_sc_hd__decap_3
XPHY_78 VGND VGND VPWR VPWR sky130_fd_sc_hd__decap_3
XFILLER_0_36_269 VGND VGND VPWR VPWR sky130_fd_sc_hd__decap_3
XPHY_67 VGND VGND VPWR VPWR sky130_fd_sc_hd__decap_3
XFILLER_0_8_171 VPWR VGND VPWR VGND sky130_ef_sc_hd__decap_12
XPHY_23 VGND VGND VPWR VPWR sky130_fd_sc_hd__decap_3
XPHY_34 VGND VGND VPWR VPWR sky130_fd_sc_hd__decap_3
XPHY_45 VGND VGND VPWR VPWR sky130_fd_sc_hd__decap_3
XPHY_56 VGND VGND VPWR VPWR sky130_fd_sc_hd__decap_3
X_0950_ u_apt.cnt\[14\] _0401_ _0407_ _0404_ u_apt.cnt\[15\] VGND VGND VPWR VPWR _0408_
+ sky130_fd_sc_hd__a32o_1
X_0881_ _0231_ _0353_ VGND VGND VPWR VPWR _0354_ sky130_fd_sc_hd__nor2_2
XFILLER_0_27_225 VGND VGND VPWR VPWR sky130_fd_sc_hd__decap_3
Xu_ro_bank.g_ro\[3\].u_ro.g_stg\[4\].u_inv_u_cell u_ro_bank.g_ro\[3\].u_ro.n\[3\]
+ VGND VGND VPWR VPWR u_ro_bank.g_ro\[3\].u_ro.n\[4\] sky130_fd_sc_hd__inv_1
X_1364_ clknet_4_5_0_clk _0146_ VGND VGND VPWR VPWR div\[31\] sky130_fd_sc_hd__dfxtp_1
XFILLER_0_37_30 VPWR VGND VPWR VGND sky130_ef_sc_hd__decap_12
X_1295_ clknet_4_14_0_clk net42 VGND VGND VPWR VPWR u_apt.cnt\[12\] sky130_fd_sc_hd__dfxtp_1
XFILLER_0_18_269 VGND VGND VPWR VPWR sky130_fd_sc_hd__fill_2
XFILLER_0_41_261 VGND VGND VPWR VPWR sky130_fd_sc_hd__fill_1
XTAP_180 VGND VPWR sky130_fd_sc_hd__tapvpwrvgnd_1
XTAP_191 VGND VPWR sky130_fd_sc_hd__tapvpwrvgnd_1
X_1080_ net23 _0506_ _0507_ VGND VGND VPWR VPWR _0508_ sky130_fd_sc_hd__a21oi_1
XFILLER_0_23_65 VPWR VGND VPWR VGND sky130_ef_sc_hd__decap_12
X_0795_ net80 _0288_ _0290_ _0278_ _0206_ VGND VGND VPWR VPWR _0042_ sky130_fd_sc_hd__o221a_1
X_0933_ _0392_ _0395_ _0239_ VGND VGND VPWR VPWR _0075_ sky130_fd_sc_hd__a21oi_1
X_0864_ _0340_ VGND VGND VPWR VPWR _0061_ sky130_fd_sc_hd__clkbuf_1
XFILLER_0_23_250 VPWR VGND VPWR VGND sky130_ef_sc_hd__decap_12
X_1347_ clknet_4_5_0_clk _0129_ VGND VGND VPWR VPWR div\[14\] sky130_fd_sc_hd__dfxtp_1
XFILLER_0_2_188 VGND VGND VPWR VPWR sky130_fd_sc_hd__decap_8
X_1278_ clknet_4_3_0_clk _0060_ VGND VGND VPWR VPWR u_apt.idx\[12\] sky130_fd_sc_hd__dfxtp_1
X_1201_ net69 _0593_ _0524_ VGND VGND VPWR VPWR _0596_ sky130_fd_sc_hd__a21boi_1
XFILLER_0_20_253 VGND VGND VPWR VPWR sky130_fd_sc_hd__fill_1
XFILLER_0_20_264 VGND VGND VPWR VPWR sky130_fd_sc_hd__fill_1
X_1063_ u_uart.clk_cnt\[9\] _0490_ _0493_ _0488_ VGND VGND VPWR VPWR _0494_ sky130_fd_sc_hd__a22o_1
X_1132_ div\[7\] div\[8\] _0537_ net93 VGND VGND VPWR VPWR _0546_ sky130_fd_sc_hd__a31o_1
X_0916_ u_apt.cnt\[7\] u_apt.cnt\[6\] _0365_ _0375_ VGND VGND VPWR VPWR _0382_ sky130_fd_sc_hd__and4_1
X_0778_ u_rct.cnt\[7\] _0271_ _0276_ _0230_ VGND VGND VPWR VPWR _0278_ sky130_fd_sc_hd__a31o_2
X_0847_ net58 _0324_ _0327_ _0172_ VGND VGND VPWR VPWR _0057_ sky130_fd_sc_hd__o211a_1
Xhold8 _0030_ VGND VGND VPWR VPWR net14 sky130_fd_sc_hd__dlygate4sd3_1
XFILLER_0_37_194 VGND VGND VPWR VPWR sky130_fd_sc_hd__decap_6
XFILLER_0_37_150 VGND VGND VPWR VPWR sky130_fd_sc_hd__decap_8
X_0632_ byte_reg\[2\] _0163_ VGND VGND VPWR VPWR _0168_ sky130_fd_sc_hd__or2_1
X_0701_ _0219_ _0220_ VGND VGND VPWR VPWR _0221_ sky130_fd_sc_hd__or2_1
X_1115_ div\[5\] div\[4\] _0531_ VGND VGND VPWR VPWR _0533_ sky130_fd_sc_hd__and3_1
X_1046_ net89 _0478_ _0481_ _0456_ VGND VGND VPWR VPWR _0102_ sky130_fd_sc_hd__o211a_1
XFILLER_0_43_120 VPWR VGND VPWR VGND sky130_ef_sc_hd__decap_12
XFILLER_0_19_161 VGND VGND VPWR VPWR sky130_fd_sc_hd__decap_6
XFILLER_0_34_197 VGND VGND VPWR VPWR sky130_fd_sc_hd__fill_1
Xclkbuf_4_0_0_clk clknet_0_clk VGND VGND VPWR VPWR clknet_4_0_0_clk sky130_fd_sc_hd__clkbuf_8
XFILLER_0_15_11 VGND VGND VPWR VPWR sky130_fd_sc_hd__fill_2
XFILLER_0_40_101 VGND VGND VPWR VPWR sky130_fd_sc_hd__fill_2
XFILLER_0_25_142 VGND VGND VPWR VPWR sky130_fd_sc_hd__decap_8
XFILLER_0_0_253 VPWR VGND VPWR VGND sky130_ef_sc_hd__decap_12
X_0615_ _0150_ _0153_ VGND VGND VPWR VPWR u_ro_bank.x sky130_fd_sc_hd__xnor2_1
XFILLER_0_15_3 VGND VGND VPWR VPWR sky130_fd_sc_hd__decap_8
XFILLER_0_48_289 VGND VGND VPWR VPWR sky130_fd_sc_hd__fill_2
X_1029_ tx_pending _0427_ VGND VGND VPWR VPWR _0469_ sky130_fd_sc_hd__nand2_1
XFILLER_0_16_153 VGND VGND VPWR VPWR sky130_fd_sc_hd__decap_3
XFILLER_0_16_197 VGND VGND VPWR VPWR sky130_fd_sc_hd__fill_2
XFILLER_0_39_223 VGND VGND VPWR VPWR sky130_fd_sc_hd__fill_1
XFILLER_0_39_201 VGND VGND VPWR VPWR sky130_fd_sc_hd__fill_2
XFILLER_0_39_289 VGND VGND VPWR VPWR sky130_fd_sc_hd__fill_2
XFILLER_0_22_101 VGND VGND VPWR VPWR sky130_fd_sc_hd__decap_8
XFILLER_0_22_123 VGND VGND VPWR VPWR sky130_fd_sc_hd__fill_1
XFILLER_0_42_64 VGND VGND VPWR VPWR sky130_fd_sc_hd__decap_8
XTAP_351 VGND VPWR sky130_fd_sc_hd__tapvpwrvgnd_1
XTAP_340 VGND VPWR sky130_fd_sc_hd__tapvpwrvgnd_1
XFILLER_0_6_75 VGND VGND VPWR VPWR sky130_fd_sc_hd__decap_4
XPHY_13 VGND VGND VPWR VPWR sky130_fd_sc_hd__decap_3
XPHY_24 VGND VGND VPWR VPWR sky130_fd_sc_hd__decap_3
XPHY_35 VGND VGND VPWR VPWR sky130_fd_sc_hd__decap_3
XPHY_46 VGND VGND VPWR VPWR sky130_fd_sc_hd__decap_3
XPHY_79 VGND VGND VPWR VPWR sky130_fd_sc_hd__decap_3
XPHY_68 VGND VGND VPWR VPWR sky130_fd_sc_hd__decap_3
XFILLER_0_8_183 VPWR VGND VPWR VGND sky130_ef_sc_hd__decap_12
XPHY_57 VGND VGND VPWR VPWR sky130_fd_sc_hd__decap_3
XFILLER_0_4_3 VGND VGND VPWR VPWR sky130_fd_sc_hd__decap_6
XFILLER_0_35_281 VGND VGND VPWR VPWR sky130_fd_sc_hd__fill_2
X_0880_ _0350_ _0348_ VGND VGND VPWR VPWR _0353_ sky130_fd_sc_hd__or2b_1
X_1363_ clknet_4_5_0_clk _0145_ VGND VGND VPWR VPWR div\[30\] sky130_fd_sc_hd__dfxtp_1
XFILLER_0_37_42 VPWR VGND VPWR VGND sky130_ef_sc_hd__decap_12
XFILLER_0_10_137 VGND VGND VPWR VPWR sky130_fd_sc_hd__decap_3
XFILLER_0_37_75 VGND VGND VPWR VPWR sky130_fd_sc_hd__fill_1
X_1294_ clknet_4_15_0_clk _0076_ VGND VGND VPWR VPWR u_apt.cnt\[11\] sky130_fd_sc_hd__dfxtp_1
XFILLER_0_5_186 VGND VGND VPWR VPWR sky130_fd_sc_hd__fill_2
XTAP_170 VGND VPWR sky130_fd_sc_hd__tapvpwrvgnd_1
XTAP_181 VGND VPWR sky130_fd_sc_hd__tapvpwrvgnd_1
XTAP_192 VGND VPWR sky130_fd_sc_hd__tapvpwrvgnd_1
X_0932_ _0374_ _0393_ _0394_ VGND VGND VPWR VPWR _0395_ sky130_fd_sc_hd__or3_1
XFILLER_0_23_77 VPWR VGND VPWR VGND sky130_ef_sc_hd__decap_12
X_0794_ _0270_ _0276_ VGND VGND VPWR VPWR _0290_ sky130_fd_sc_hd__and2b_1
X_0863_ _0338_ _0251_ _0339_ VGND VGND VPWR VPWR _0340_ sky130_fd_sc_hd__and3b_1
XFILLER_0_23_240 VGND VGND VPWR VPWR sky130_fd_sc_hd__decap_4
XFILLER_0_23_262 VGND VGND VPWR VPWR sky130_fd_sc_hd__decap_3
XFILLER_0_48_85 VPWR VGND VPWR VGND sky130_ef_sc_hd__decap_12
XFILLER_0_48_41 VGND VGND VPWR VPWR sky130_fd_sc_hd__decap_6
X_1346_ clknet_4_5_0_clk _0128_ VGND VGND VPWR VPWR div\[13\] sky130_fd_sc_hd__dfxtp_1
X_1277_ clknet_4_3_0_clk _0059_ VGND VGND VPWR VPWR u_apt.idx\[11\] sky130_fd_sc_hd__dfxtp_1
Xu_ro_bank.g_ro\[5\].u_ro.g_stg\[8\].u_inv_u_cell u_ro_bank.g_ro\[5\].u_ro.n\[7\]
+ VGND VGND VPWR VPWR u_ro_bank.g_ro\[5\].u_ro.n\[8\] sky130_fd_sc_hd__inv_1
XFILLER_0_20_221 VPWR VGND VPWR VGND sky130_ef_sc_hd__decap_12
X_1200_ _0595_ VGND VGND VPWR VPWR _0142_ sky130_fd_sc_hd__clkbuf_1
XFILLER_0_34_43 VGND VGND VPWR VPWR sky130_fd_sc_hd__decap_8
X_1062_ u_uart.clk_cnt\[9\] _0473_ VGND VGND VPWR VPWR _0493_ sky130_fd_sc_hd__nor2_1
X_1131_ net93 div\[8\] VGND VGND VPWR VPWR _0545_ sky130_fd_sc_hd__nand2_1
X_0915_ _0236_ _0381_ VGND VGND VPWR VPWR _0071_ sky130_fd_sc_hd__nor2_1
X_0777_ u_rct.cnt\[7\] _0271_ _0276_ _0230_ VGND VGND VPWR VPWR _0277_ sky130_fd_sc_hd__a31oi_4
XFILLER_0_11_221 VGND VGND VPWR VPWR sky130_fd_sc_hd__decap_3
X_0846_ _0326_ VGND VGND VPWR VPWR _0327_ sky130_fd_sc_hd__inv_2
XFILLER_0_45_3 VPWR VGND VPWR VGND sky130_ef_sc_hd__decap_12
X_1329_ clknet_4_9_0_clk _0111_ VGND VGND VPWR VPWR u_uart.clk_cnt\[13\] sky130_fd_sc_hd__dfxtp_1
Xhold9 warm\[7\] VGND VGND VPWR VPWR net15 sky130_fd_sc_hd__dlygate4sd3_1
X_0700_ div\[1\] div\[0\] div\[2\] VGND VGND VPWR VPWR _0220_ sky130_fd_sc_hd__nand3_1
X_0631_ net46 _0162_ _0167_ _0166_ VGND VGND VPWR VPWR _0001_ sky130_fd_sc_hd__o211a_1
X_1114_ net54 _0531_ _0532_ VGND VGND VPWR VPWR _0119_ sky130_fd_sc_hd__a21oi_1
X_1045_ u_uart.clk_cnt\[4\] _0457_ _0480_ _0425_ VGND VGND VPWR VPWR _0481_ sky130_fd_sc_hd__a22o_1
XFILLER_0_43_132 VPWR VGND VPWR VGND sky130_ef_sc_hd__decap_12
XFILLER_0_43_110 VGND VGND VPWR VPWR sky130_fd_sc_hd__fill_2
X_0829_ net40 _0314_ _0206_ VGND VGND VPWR VPWR _0315_ sky130_fd_sc_hd__o21ai_1
XFILLER_0_34_121 VGND VGND VPWR VPWR sky130_fd_sc_hd__fill_1
XFILLER_0_15_34 VGND VGND VPWR VPWR sky130_fd_sc_hd__decap_8
XFILLER_0_40_124 VGND VGND VPWR VPWR sky130_fd_sc_hd__fill_1
XFILLER_0_31_44 VPWR VGND VPWR VGND sky130_ef_sc_hd__decap_12
XFILLER_0_25_187 VGND VGND VPWR VPWR sky130_fd_sc_hd__decap_3
XFILLER_0_0_221 VGND VGND VPWR VPWR sky130_fd_sc_hd__decap_3
XFILLER_0_0_265 VPWR VGND VPWR VGND sky130_ef_sc_hd__decap_12
X_0614_ _0151_ _0152_ VGND VGND VPWR VPWR _0153_ sky130_fd_sc_hd__xnor2_1
X_1028_ net103 _0459_ _0468_ _0456_ VGND VGND VPWR VPWR _0097_ sky130_fd_sc_hd__o211a_1
XFILLER_0_31_124 VGND VGND VPWR VPWR sky130_fd_sc_hd__decap_4
Xu_ro_bank.g_ro\[4\].u_ro.g_stg\[4\].u_inv_u_cell u_ro_bank.g_ro\[4\].u_ro.n\[3\]
+ VGND VGND VPWR VPWR u_ro_bank.g_ro\[4\].u_ro.n\[4\] sky130_fd_sc_hd__inv_1
XFILLER_0_45_216 VGND VGND VPWR VPWR sky130_fd_sc_hd__fill_1
XFILLER_0_42_76 VGND VGND VPWR VPWR sky130_fd_sc_hd__decap_8
XTAP_352 VGND VPWR sky130_fd_sc_hd__tapvpwrvgnd_1
XTAP_341 VGND VPWR sky130_fd_sc_hd__tapvpwrvgnd_1
XTAP_330 VGND VPWR sky130_fd_sc_hd__tapvpwrvgnd_1
XPHY_69 VGND VGND VPWR VPWR sky130_fd_sc_hd__decap_3
XPHY_14 VGND VGND VPWR VPWR sky130_fd_sc_hd__decap_3
XPHY_25 VGND VGND VPWR VPWR sky130_fd_sc_hd__decap_3
XPHY_36 VGND VGND VPWR VPWR sky130_fd_sc_hd__decap_3
XPHY_47 VGND VGND VPWR VPWR sky130_fd_sc_hd__decap_3
XPHY_58 VGND VGND VPWR VPWR sky130_fd_sc_hd__decap_3
XFILLER_0_8_195 VGND VGND VPWR VPWR sky130_fd_sc_hd__fill_1
X_1362_ clknet_4_7_0_clk _0144_ VGND VGND VPWR VPWR div\[29\] sky130_fd_sc_hd__dfxtp_1
XFILLER_0_37_54 VGND VGND VPWR VPWR sky130_fd_sc_hd__fill_2
X_1293_ clknet_4_15_0_clk _0075_ VGND VGND VPWR VPWR u_apt.cnt\[10\] sky130_fd_sc_hd__dfxtp_1
XFILLER_0_18_249 VGND VGND VPWR VPWR sky130_fd_sc_hd__decap_3
XTAP_160 VGND VPWR sky130_fd_sc_hd__tapvpwrvgnd_1
XTAP_171 VGND VPWR sky130_fd_sc_hd__tapvpwrvgnd_1
XTAP_182 VGND VPWR sky130_fd_sc_hd__tapvpwrvgnd_1
XTAP_193 VGND VPWR sky130_fd_sc_hd__tapvpwrvgnd_1
XFILLER_0_32_241 VGND VGND VPWR VPWR sky130_fd_sc_hd__fill_2
XFILLER_0_32_285 VGND VGND VPWR VPWR sky130_fd_sc_hd__decap_6
X_0931_ u_apt.cnt\[9\] _0388_ u_apt.cnt\[10\] VGND VGND VPWR VPWR _0394_ sky130_fd_sc_hd__a21oi_1
X_0862_ u_apt.idx\[13\] _0335_ VGND VGND VPWR VPWR _0339_ sky130_fd_sc_hd__or2_1
XFILLER_0_23_89 VPWR VGND VPWR VGND sky130_ef_sc_hd__decap_12
X_0793_ _0287_ _0288_ _0289_ VGND VGND VPWR VPWR _0041_ sky130_fd_sc_hd__nor3_1
Xu_ro_bank.g_ro\[7\].u_ro.g_stg\[16\].u_inv_u_cell u_ro_bank.g_ro\[7\].u_ro.n\[15\]
+ VGND VGND VPWR VPWR u_ro_bank.g_ro\[7\].u_ro.n\[16\] sky130_fd_sc_hd__inv_1
XFILLER_0_48_97 VPWR VGND VPWR VGND sky130_ef_sc_hd__decap_12
X_1345_ clknet_4_5_0_clk _0127_ VGND VGND VPWR VPWR div\[12\] sky130_fd_sc_hd__dfxtp_1
XFILLER_0_3_22 VPWR VGND VPWR VGND sky130_ef_sc_hd__decap_12
X_1276_ clknet_4_3_0_clk _0058_ VGND VGND VPWR VPWR u_apt.idx\[10\] sky130_fd_sc_hd__dfxtp_1
XFILLER_0_20_200 VGND VGND VPWR VPWR sky130_fd_sc_hd__fill_1
XFILLER_0_20_233 VGND VGND VPWR VPWR sky130_fd_sc_hd__fill_2
X_1130_ _0543_ _0540_ _0544_ _0521_ VGND VGND VPWR VPWR _0123_ sky130_fd_sc_hd__o211a_1
X_1061_ _0492_ VGND VGND VPWR VPWR _0106_ sky130_fd_sc_hd__clkbuf_1
X_0914_ u_apt.cnt\[6\] _0356_ _0374_ _0380_ VGND VGND VPWR VPWR _0381_ sky130_fd_sc_hd__o2bb2a_1
X_0845_ u_apt.idx\[9\] u_apt.idx\[8\] _0321_ VGND VGND VPWR VPWR _0326_ sky130_fd_sc_hd__and3_1
X_0776_ _0272_ _0275_ VGND VGND VPWR VPWR _0276_ sky130_fd_sc_hd__nor2b_4
XFILLER_0_11_244 VPWR VGND VPWR VGND sky130_ef_sc_hd__decap_12
XFILLER_0_11_277 VGND VGND VPWR VPWR sky130_fd_sc_hd__decap_3
X_1259_ clknet_4_13_0_clk _0041_ VGND VGND VPWR VPWR u_rct.cnt\[3\] sky130_fd_sc_hd__dfxtp_1
XFILLER_0_38_3 VGND VGND VPWR VPWR sky130_fd_sc_hd__fill_1
X_1328_ clknet_4_9_0_clk _0110_ VGND VGND VPWR VPWR u_uart.clk_cnt\[12\] sky130_fd_sc_hd__dfxtp_1
XFILLER_0_46_141 VPWR VGND VPWR VGND sky130_ef_sc_hd__decap_12
XFILLER_0_20_35 VGND VGND VPWR VPWR sky130_fd_sc_hd__fill_1
X_0630_ byte_reg\[1\] _0163_ VGND VGND VPWR VPWR _0167_ sky130_fd_sc_hd__or2_1
XFILLER_0_29_55 VGND VGND VPWR VPWR sky130_fd_sc_hd__fill_1
X_1113_ net54 _0531_ _0521_ VGND VGND VPWR VPWR _0532_ sky130_fd_sc_hd__o21ai_1
X_1044_ u_uart.clk_cnt\[4\] _0478_ VGND VGND VPWR VPWR _0480_ sky130_fd_sc_hd__nand2_1
XFILLER_0_28_141 VPWR VGND VPWR VGND sky130_ef_sc_hd__decap_12
XFILLER_0_43_144 VPWR VGND VPWR VGND sky130_ef_sc_hd__decap_12
X_0828_ _0311_ _0309_ _0314_ _0239_ VGND VGND VPWR VPWR _0051_ sky130_fd_sc_hd__a211oi_1
X_0759_ net64 _0237_ VGND VGND VPWR VPWR _0264_ sky130_fd_sc_hd__and2_1
XFILLER_0_3_241 VPWR VGND VPWR VGND sky130_ef_sc_hd__decap_12
XFILLER_0_9_65 VGND VGND VPWR VPWR sky130_fd_sc_hd__fill_1
X_0613_ u_ro_bank.g_ro\[7\].u_ro.n\[16\] u_ro_bank.g_ro\[6\].u_ro.n\[14\] VGND VGND
+ VPWR VPWR _0152_ sky130_fd_sc_hd__xnor2_1
XFILLER_0_25_199 VGND VGND VPWR VPWR sky130_fd_sc_hd__decap_8
XFILLER_0_0_277 VGND VGND VPWR VPWR sky130_fd_sc_hd__decap_3
XFILLER_0_48_225 VGND VGND VPWR VPWR sky130_fd_sc_hd__fill_2
X_1027_ _0425_ _0467_ _0439_ VGND VGND VPWR VPWR _0468_ sky130_fd_sc_hd__a21o_1
XFILLER_0_39_269 VGND VGND VPWR VPWR sky130_fd_sc_hd__decap_8
XFILLER_0_39_214 VGND VGND VPWR VPWR sky130_fd_sc_hd__fill_1
Xhold90 u_apt.idx\[0\] VGND VGND VPWR VPWR net96 sky130_fd_sc_hd__dlygate4sd3_1
XFILLER_0_9_119 VGND VGND VPWR VPWR sky130_fd_sc_hd__decap_8
XTAP_342 VGND VPWR sky130_fd_sc_hd__tapvpwrvgnd_1
XTAP_331 VGND VPWR sky130_fd_sc_hd__tapvpwrvgnd_1
XTAP_320 VGND VPWR sky130_fd_sc_hd__tapvpwrvgnd_1
XFILLER_0_20_3 VPWR VGND VPWR VGND sky130_ef_sc_hd__decap_12
XPHY_15 VGND VGND VPWR VPWR sky130_fd_sc_hd__decap_3
XPHY_26 VGND VGND VPWR VPWR sky130_fd_sc_hd__decap_3
XPHY_37 VGND VGND VPWR VPWR sky130_fd_sc_hd__decap_3
XPHY_48 VGND VGND VPWR VPWR sky130_fd_sc_hd__decap_3
XPHY_59 VGND VGND VPWR VPWR sky130_fd_sc_hd__decap_3
XFILLER_0_44_250 VGND VGND VPWR VPWR sky130_fd_sc_hd__fill_2
XFILLER_0_36_239 VGND VGND VPWR VPWR sky130_fd_sc_hd__fill_1
XFILLER_0_8_141 VGND VGND VPWR VPWR sky130_fd_sc_hd__fill_1
XFILLER_0_42_209 VPWR VGND VPWR VGND sky130_ef_sc_hd__decap_12
XFILLER_0_12_36 VPWR VGND VPWR VGND sky130_ef_sc_hd__decap_12
XFILLER_0_27_217 VGND VGND VPWR VPWR sky130_fd_sc_hd__decap_6
X_1361_ clknet_4_7_0_clk _0143_ VGND VGND VPWR VPWR div\[28\] sky130_fd_sc_hd__dfxtp_1
X_1292_ clknet_4_13_0_clk _0074_ VGND VGND VPWR VPWR u_apt.cnt\[9\] sky130_fd_sc_hd__dfxtp_1
Xu_ro_bank.g_ro\[6\].u_ro.g_stg\[8\].u_inv_u_cell u_ro_bank.g_ro\[6\].u_ro.n\[7\]
+ VGND VGND VPWR VPWR u_ro_bank.g_ro\[6\].u_ro.n\[8\] sky130_fd_sc_hd__inv_1
XTAP_150 VGND VPWR sky130_fd_sc_hd__tapvpwrvgnd_1
Xu_ro_bank.g_ro\[6\].u_ro.g_stg\[13\].u_inv_u_cell u_ro_bank.g_ro\[6\].u_ro.n\[12\]
+ VGND VGND VPWR VPWR u_ro_bank.g_ro\[6\].u_ro.n\[13\] sky130_fd_sc_hd__inv_1
XTAP_161 VGND VPWR sky130_fd_sc_hd__tapvpwrvgnd_1
XTAP_172 VGND VPWR sky130_fd_sc_hd__tapvpwrvgnd_1
XTAP_183 VGND VPWR sky130_fd_sc_hd__tapvpwrvgnd_1
XTAP_194 VGND VPWR sky130_fd_sc_hd__tapvpwrvgnd_1
XFILLER_0_32_264 VGND VGND VPWR VPWR sky130_fd_sc_hd__fill_2
X_0930_ u_apt.cnt\[10\] u_apt.cnt\[9\] _0388_ VGND VGND VPWR VPWR _0393_ sky130_fd_sc_hd__and3_1
X_0792_ _0231_ _0276_ _0237_ VGND VGND VPWR VPWR _0289_ sky130_fd_sc_hd__o21ai_1
X_0861_ u_apt.idx\[13\] _0335_ VGND VGND VPWR VPWR _0338_ sky130_fd_sc_hd__and2_1
XFILLER_0_23_57 VGND VGND VPWR VPWR sky130_fd_sc_hd__decap_3
XFILLER_0_48_54 VGND VGND VPWR VPWR sky130_fd_sc_hd__fill_2
X_1344_ clknet_4_4_0_clk _0126_ VGND VGND VPWR VPWR div\[11\] sky130_fd_sc_hd__dfxtp_1
XFILLER_0_3_34 VGND VGND VPWR VPWR sky130_fd_sc_hd__decap_6
X_1275_ clknet_4_1_0_clk _0057_ VGND VGND VPWR VPWR u_apt.idx\[9\] sky130_fd_sc_hd__dfxtp_1
XFILLER_0_14_220 VGND VGND VPWR VPWR sky130_fd_sc_hd__decap_6
XFILLER_0_14_264 VGND VGND VPWR VPWR sky130_fd_sc_hd__decap_6
XFILLER_0_20_289 VGND VGND VPWR VPWR sky130_fd_sc_hd__fill_2
X_1060_ _0237_ _0491_ VGND VGND VPWR VPWR _0492_ sky130_fd_sc_hd__and2_1
XFILLER_0_18_79 VGND VGND VPWR VPWR sky130_fd_sc_hd__decap_4
X_0913_ u_apt.cnt\[6\] _0376_ VGND VGND VPWR VPWR _0380_ sky130_fd_sc_hd__xor2_1
X_0775_ u_rct.cnt\[4\] u_rct.cnt\[3\] _0273_ _0274_ VGND VGND VPWR VPWR _0275_ sky130_fd_sc_hd__or4_1
X_0844_ _0324_ _0325_ VGND VGND VPWR VPWR _0056_ sky130_fd_sc_hd__nor2_1
XFILLER_0_11_256 VGND VGND VPWR VPWR sky130_fd_sc_hd__decap_8
XFILLER_0_11_289 VGND VGND VPWR VPWR sky130_fd_sc_hd__fill_2
X_1189_ _0587_ VGND VGND VPWR VPWR _0139_ sky130_fd_sc_hd__clkbuf_1
X_1258_ clknet_4_7_0_clk _0040_ VGND VGND VPWR VPWR u_rct.cnt\[2\] sky130_fd_sc_hd__dfxtp_1
X_1327_ clknet_4_8_0_clk _0109_ VGND VGND VPWR VPWR u_uart.clk_cnt\[11\] sky130_fd_sc_hd__dfxtp_1
XFILLER_0_46_153 VPWR VGND VPWR VGND sky130_ef_sc_hd__decap_12
Xu_ro_bank.g_ro\[5\].u_ro.g_stg\[4\].u_inv_u_cell u_ro_bank.g_ro\[5\].u_ro.n\[3\]
+ VGND VGND VPWR VPWR u_ro_bank.g_ro\[5\].u_ro.n\[4\] sky130_fd_sc_hd__inv_1
XFILLER_0_29_67 VPWR VGND VPWR VGND sky130_ef_sc_hd__decap_12
XFILLER_0_45_66 VGND VGND VPWR VPWR sky130_fd_sc_hd__fill_2
X_1043_ net62 _0474_ _0479_ _0456_ VGND VGND VPWR VPWR _0101_ sky130_fd_sc_hd__o211a_1
X_1112_ div\[1\] div\[0\] div\[3\] div\[2\] VGND VGND VPWR VPWR _0531_ sky130_fd_sc_hd__and4_1
XFILLER_0_0_57 VPWR VGND VPWR VGND sky130_ef_sc_hd__decap_12
XFILLER_0_28_153 VGND VGND VPWR VPWR sky130_fd_sc_hd__fill_1
XFILLER_0_28_197 VPWR VGND VPWR VGND sky130_ef_sc_hd__decap_12
XFILLER_0_43_156 VPWR VGND VPWR VGND sky130_ef_sc_hd__decap_12
X_0827_ _0230_ _0313_ VGND VGND VPWR VPWR _0314_ sky130_fd_sc_hd__nor2_2
XFILLER_0_3_253 VPWR VGND VPWR VGND sky130_ef_sc_hd__decap_12
X_0758_ _0263_ VGND VGND VPWR VPWR _0032_ sky130_fd_sc_hd__clkbuf_1
XFILLER_0_9_55 VGND VGND VPWR VPWR sky130_fd_sc_hd__fill_1
XFILLER_0_10_91 VGND VGND VPWR VPWR sky130_fd_sc_hd__fill_1
X_0689_ _0210_ VGND VGND VPWR VPWR _0016_ sky130_fd_sc_hd__clkbuf_1
XFILLER_0_19_120 VPWR VGND VPWR VGND sky130_ef_sc_hd__decap_12
XFILLER_0_31_57 VGND VGND VPWR VPWR sky130_fd_sc_hd__fill_2
XFILLER_0_25_101 VGND VGND VPWR VPWR sky130_fd_sc_hd__fill_1
XFILLER_0_40_115 VGND VGND VPWR VPWR sky130_fd_sc_hd__decap_4
X_0612_ u_ro_bank.g_ro\[3\].u_ro.n\[8\] u_ro_bank.g_ro\[2\].u_ro.n\[6\] VGND VGND
+ VPWR VPWR _0151_ sky130_fd_sc_hd__xor2_1
XFILLER_0_0_289 VGND VGND VPWR VPWR sky130_fd_sc_hd__fill_2
X_1026_ u_uart.bit_cnt\[3\] _0464_ _0462_ _0429_ VGND VGND VPWR VPWR _0467_ sky130_fd_sc_hd__o31ai_1
XFILLER_0_16_101 VGND VGND VPWR VPWR sky130_fd_sc_hd__decap_3
XFILLER_0_47_281 VGND VGND VPWR VPWR sky130_fd_sc_hd__decap_8
Xhold80 u_apt.cnt\[0\] VGND VGND VPWR VPWR net86 sky130_fd_sc_hd__dlygate4sd3_1
XFILLER_0_26_46 VGND VGND VPWR VPWR sky130_fd_sc_hd__fill_1
Xhold91 div\[8\] VGND VGND VPWR VPWR net97 sky130_fd_sc_hd__dlygate4sd3_1
XTAP_332 VGND VPWR sky130_fd_sc_hd__tapvpwrvgnd_1
XTAP_321 VGND VPWR sky130_fd_sc_hd__tapvpwrvgnd_1
XTAP_310 VGND VPWR sky130_fd_sc_hd__tapvpwrvgnd_1
XFILLER_0_6_56 VPWR VGND VPWR VGND sky130_ef_sc_hd__decap_12
XFILLER_0_21_181 VGND VGND VPWR VPWR sky130_fd_sc_hd__decap_8
XTAP_343 VGND VPWR sky130_fd_sc_hd__tapvpwrvgnd_1
XFILLER_0_13_3 VPWR VGND VPWR VGND sky130_ef_sc_hd__decap_12
XPHY_16 VGND VGND VPWR VPWR sky130_fd_sc_hd__decap_3
X_1009_ _0441_ _0454_ VGND VGND VPWR VPWR _0455_ sky130_fd_sc_hd__or2_1
XPHY_27 VGND VGND VPWR VPWR sky130_fd_sc_hd__decap_3
XPHY_38 VGND VGND VPWR VPWR sky130_fd_sc_hd__decap_3
XPHY_49 VGND VGND VPWR VPWR sky130_fd_sc_hd__decap_3
XFILLER_0_29_281 VGND VGND VPWR VPWR sky130_fd_sc_hd__decap_8
Xu_ro_bank.g_ro\[5\].u_ro.g_stg\[10\].u_inv_u_cell u_ro_bank.g_ro\[5\].u_ro.n\[9\]
+ VGND VGND VPWR VPWR u_ro_bank.g_ro\[5\].u_ro.n\[10\] sky130_fd_sc_hd__inv_1
XFILLER_0_12_26 VGND VGND VPWR VPWR sky130_fd_sc_hd__fill_2
XFILLER_0_12_48 VPWR VGND VPWR VGND sky130_ef_sc_hd__decap_12
X_1360_ clknet_4_7_0_clk _0142_ VGND VGND VPWR VPWR div\[27\] sky130_fd_sc_hd__dfxtp_1
Xoutput2 net2 VGND VGND VPWR VPWR dbg_raw_bit sky130_fd_sc_hd__clkbuf_4
X_1291_ clknet_4_13_0_clk _0073_ VGND VGND VPWR VPWR u_apt.cnt\[8\] sky130_fd_sc_hd__dfxtp_1
XFILLER_0_37_23 VGND VGND VPWR VPWR sky130_fd_sc_hd__fill_2
XFILLER_0_5_178 VGND VGND VPWR VPWR sky130_fd_sc_hd__decap_8
XFILLER_0_5_156 VPWR VGND VPWR VGND sky130_ef_sc_hd__decap_12
XFILLER_0_5_134 VGND VGND VPWR VPWR sky130_fd_sc_hd__decap_6
XFILLER_0_5_101 VGND VGND VPWR VPWR sky130_fd_sc_hd__decap_8
XTAP_140 VGND VPWR sky130_fd_sc_hd__tapvpwrvgnd_1
XTAP_151 VGND VPWR sky130_fd_sc_hd__tapvpwrvgnd_1
XTAP_162 VGND VPWR sky130_fd_sc_hd__tapvpwrvgnd_1
XTAP_173 VGND VPWR sky130_fd_sc_hd__tapvpwrvgnd_1
XTAP_184 VGND VPWR sky130_fd_sc_hd__tapvpwrvgnd_1
XTAP_195 VGND VPWR sky130_fd_sc_hd__tapvpwrvgnd_1
XFILLER_0_2_3 VGND VGND VPWR VPWR sky130_fd_sc_hd__decap_8
X_0791_ u_rct.cnt\[3\] _0269_ _0277_ VGND VGND VPWR VPWR _0288_ sky130_fd_sc_hd__and3_1
X_0860_ _0337_ VGND VGND VPWR VPWR _0060_ sky130_fd_sc_hd__clkbuf_1
X_1343_ clknet_4_4_0_clk _0125_ VGND VGND VPWR VPWR div\[10\] sky130_fd_sc_hd__dfxtp_1
XFILLER_0_3_57 VPWR VGND VPWR VGND sky130_ef_sc_hd__decap_12
X_1274_ clknet_4_6_0_clk _0056_ VGND VGND VPWR VPWR u_apt.idx\[8\] sky130_fd_sc_hd__dfxtp_1
X_0989_ u_uart.bit_cnt\[3\] _0424_ _0439_ VGND VGND VPWR VPWR _0441_ sky130_fd_sc_hd__a21o_1
XFILLER_0_1_192 VGND VGND VPWR VPWR sky130_fd_sc_hd__decap_8
X_0912_ _0236_ _0379_ VGND VGND VPWR VPWR _0070_ sky130_fd_sc_hd__nor2_1
X_0774_ u_rct.cnt\[1\] u_rct.cnt\[0\] VGND VGND VPWR VPWR _0274_ sky130_fd_sc_hd__or2_1
XFILLER_0_11_213 VGND VGND VPWR VPWR sky130_fd_sc_hd__decap_8
X_0843_ net74 _0321_ _0206_ VGND VGND VPWR VPWR _0325_ sky130_fd_sc_hd__o21ai_1
X_1326_ clknet_4_8_0_clk _0108_ VGND VGND VPWR VPWR u_uart.clk_cnt\[10\] sky130_fd_sc_hd__dfxtp_1
X_1188_ _0585_ _0535_ _0586_ VGND VGND VPWR VPWR _0587_ sky130_fd_sc_hd__and3b_1
X_1257_ clknet_4_13_0_clk _0039_ VGND VGND VPWR VPWR u_rct.cnt\[1\] sky130_fd_sc_hd__dfxtp_1
XFILLER_0_46_165 VGND VGND VPWR VPWR sky130_fd_sc_hd__decap_8
Xu_ro_bank.g_ro\[7\].u_ro.g_stg\[12\].u_inv_u_cell u_ro_bank.g_ro\[7\].u_ro.n\[11\]
+ VGND VGND VPWR VPWR u_ro_bank.g_ro\[7\].u_ro.n\[12\] sky130_fd_sc_hd__inv_1
XFILLER_0_20_15 VPWR VGND VPWR VGND sky130_ef_sc_hd__decap_12
XFILLER_0_29_24 VGND VGND VPWR VPWR sky130_fd_sc_hd__fill_2
XFILLER_0_29_57 VGND VGND VPWR VPWR sky130_fd_sc_hd__decap_3
XFILLER_0_29_79 VPWR VGND VPWR VGND sky130_ef_sc_hd__decap_12
X_1042_ _0427_ _0478_ _0457_ u_uart.clk_cnt\[3\] VGND VGND VPWR VPWR _0479_ sky130_fd_sc_hd__a2bb2o_1
X_1111_ _0530_ VGND VGND VPWR VPWR _0118_ sky130_fd_sc_hd__clkbuf_1
XFILLER_0_0_69 VPWR VGND VPWR VGND sky130_ef_sc_hd__decap_12
XFILLER_0_9_34 VGND VGND VPWR VPWR sky130_fd_sc_hd__decap_6
X_0826_ _0311_ _0312_ _0304_ VGND VGND VPWR VPWR _0313_ sky130_fd_sc_hd__or3_1
X_0757_ net71 _0237_ VGND VGND VPWR VPWR _0263_ sky130_fd_sc_hd__and2_1
XFILLER_0_3_265 VPWR VGND VPWR VGND sky130_ef_sc_hd__decap_12
X_0688_ _0201_ _0194_ _0209_ VGND VGND VPWR VPWR _0210_ sky130_fd_sc_hd__and3_1
XFILLER_0_43_3 VPWR VGND VPWR VGND sky130_ef_sc_hd__decap_12
Xclkbuf_4_15_0_clk clknet_0_clk VGND VGND VPWR VPWR clknet_4_15_0_clk sky130_fd_sc_hd__clkbuf_8
X_1309_ clknet_4_10_0_clk _0091_ VGND VGND VPWR VPWR u_uart.shreg\[5\] sky130_fd_sc_hd__dfxtp_1
XFILLER_0_19_132 VPWR VGND VPWR VGND sky130_ef_sc_hd__decap_12
XFILLER_0_34_157 VGND VGND VPWR VPWR sky130_fd_sc_hd__fill_2
X_0611_ _0148_ _0149_ VGND VGND VPWR VPWR _0150_ sky130_fd_sc_hd__xnor2_1
X_1025_ _0439_ _0465_ _0466_ _0456_ VGND VGND VPWR VPWR _0096_ sky130_fd_sc_hd__o211a_1
X_0809_ u_rct.cnt\[4\] u_rct.cnt\[3\] u_rct.cnt\[5\] VGND VGND VPWR VPWR _0300_ sky130_fd_sc_hd__o21a_1
XFILLER_0_24_190 VGND VGND VPWR VPWR sky130_fd_sc_hd__decap_6
Xu_ro_bank.g_ro\[7\].u_ro.g_stg\[8\].u_inv_u_cell u_ro_bank.g_ro\[7\].u_ro.n\[7\]
+ VGND VGND VPWR VPWR u_ro_bank.g_ro\[7\].u_ro.n\[8\] sky130_fd_sc_hd__inv_1
Xhold92 div\[23\] VGND VGND VPWR VPWR net98 sky130_fd_sc_hd__dlygate4sd3_1
Xhold81 u_rct.cnt\[1\] VGND VGND VPWR VPWR net87 sky130_fd_sc_hd__dlygate4sd3_1
Xhold70 u_uart.bit_cnt\[0\] VGND VGND VPWR VPWR net76 sky130_fd_sc_hd__dlygate4sd3_1
XFILLER_0_26_25 VGND VGND VPWR VPWR sky130_fd_sc_hd__decap_3
XFILLER_0_13_105 VGND VGND VPWR VPWR sky130_fd_sc_hd__fill_2
XTAP_344 VGND VPWR sky130_fd_sc_hd__tapvpwrvgnd_1
XTAP_333 VGND VPWR sky130_fd_sc_hd__tapvpwrvgnd_1
XTAP_322 VGND VPWR sky130_fd_sc_hd__tapvpwrvgnd_1
XTAP_311 VGND VPWR sky130_fd_sc_hd__tapvpwrvgnd_1
XTAP_300 VGND VPWR sky130_fd_sc_hd__tapvpwrvgnd_1
XFILLER_0_6_68 VGND VGND VPWR VPWR sky130_fd_sc_hd__decap_4
XPHY_17 VGND VGND VPWR VPWR sky130_fd_sc_hd__decap_3
XPHY_28 VGND VGND VPWR VPWR sky130_fd_sc_hd__decap_3
X_1008_ u_uart.tx_data\[6\] u_uart.shreg\[7\] _0424_ VGND VGND VPWR VPWR _0454_ sky130_fd_sc_hd__mux2_1
XPHY_39 VGND VGND VPWR VPWR sky130_fd_sc_hd__decap_3
XFILLER_0_35_263 VPWR VGND VPWR VGND sky130_ef_sc_hd__decap_12
Xoutput3 net3 VGND VGND VPWR VPWR dbg_raw_valid sky130_fd_sc_hd__clkbuf_4
X_1290_ clknet_4_15_0_clk _0072_ VGND VGND VPWR VPWR u_apt.cnt\[7\] sky130_fd_sc_hd__dfxtp_1
XFILLER_0_37_57 VPWR VGND VPWR VGND sky130_ef_sc_hd__decap_12
XFILLER_0_5_113 VGND VGND VPWR VPWR sky130_fd_sc_hd__decap_4
XTAP_141 VGND VPWR sky130_fd_sc_hd__tapvpwrvgnd_1
XTAP_130 VGND VPWR sky130_fd_sc_hd__tapvpwrvgnd_1
XTAP_152 VGND VPWR sky130_fd_sc_hd__tapvpwrvgnd_1
XTAP_163 VGND VPWR sky130_fd_sc_hd__tapvpwrvgnd_1
XTAP_174 VGND VPWR sky130_fd_sc_hd__tapvpwrvgnd_1
XTAP_185 VGND VPWR sky130_fd_sc_hd__tapvpwrvgnd_1
XTAP_196 VGND VPWR sky130_fd_sc_hd__tapvpwrvgnd_1
XFILLER_0_17_263 VGND VGND VPWR VPWR sky130_fd_sc_hd__fill_1
XFILLER_0_23_15 VPWR VGND VPWR VGND sky130_ef_sc_hd__decap_12
X_0790_ _0269_ _0277_ net79 VGND VGND VPWR VPWR _0287_ sky130_fd_sc_hd__a21oi_1
XFILLER_0_23_277 VGND VGND VPWR VPWR sky130_fd_sc_hd__decap_3
X_1342_ clknet_4_4_0_clk _0124_ VGND VGND VPWR VPWR div\[9\] sky130_fd_sc_hd__dfxtp_1
X_1273_ clknet_4_12_0_clk _0055_ VGND VGND VPWR VPWR u_apt.idx\[7\] sky130_fd_sc_hd__dfxtp_1
XFILLER_0_3_69 VPWR VGND VPWR VGND sky130_ef_sc_hd__decap_12
X_0988_ u_uart.bit_cnt\[3\] _0437_ _0439_ VGND VGND VPWR VPWR _0440_ sky130_fd_sc_hd__a21oi_4
Xu_ro_bank.g_ro\[6\].u_ro.g_stg\[4\].u_inv_u_cell u_ro_bank.g_ro\[6\].u_ro.n\[3\]
+ VGND VGND VPWR VPWR u_ro_bank.g_ro\[6\].u_ro.n\[4\] sky130_fd_sc_hd__inv_1
XFILLER_0_13_92 VGND VGND VPWR VPWR sky130_fd_sc_hd__decap_8
XFILLER_0_18_15 VPWR VGND VPWR VGND sky130_ef_sc_hd__decap_12
X_0911_ u_apt.cnt\[5\] _0356_ _0374_ _0378_ VGND VGND VPWR VPWR _0379_ sky130_fd_sc_hd__o2bb2a_1
X_0842_ u_apt.idx\[8\] _0321_ VGND VGND VPWR VPWR _0324_ sky130_fd_sc_hd__and2_1
X_0773_ u_rct.cnt\[7\] u_rct.cnt\[6\] u_rct.cnt\[5\] u_rct.cnt\[2\] VGND VGND VPWR
+ VPWR _0273_ sky130_fd_sc_hd__or4_1
XFILLER_0_11_225 VGND VGND VPWR VPWR sky130_fd_sc_hd__decap_6
X_1256_ clknet_4_7_0_clk _0038_ VGND VGND VPWR VPWR u_rct.cnt\[0\] sky130_fd_sc_hd__dfxtp_1
X_1325_ clknet_4_2_0_clk _0107_ VGND VGND VPWR VPWR u_uart.clk_cnt\[9\] sky130_fd_sc_hd__dfxtp_1
X_1187_ div\[23\] div\[22\] _0577_ div\[24\] VGND VGND VPWR VPWR _0586_ sky130_fd_sc_hd__a31o_1
XFILLER_0_37_111 VGND VGND VPWR VPWR sky130_fd_sc_hd__fill_1
XFILLER_0_20_27 VGND VGND VPWR VPWR sky130_fd_sc_hd__fill_1
XFILLER_0_29_14 VGND VGND VPWR VPWR sky130_fd_sc_hd__decap_4
XFILLER_0_45_35 VGND VGND VPWR VPWR sky130_fd_sc_hd__fill_1
X_1110_ _0165_ _0221_ _0529_ VGND VGND VPWR VPWR _0530_ sky130_fd_sc_hd__and3_1
X_1041_ u_uart.clk_cnt\[3\] _0474_ VGND VGND VPWR VPWR _0478_ sky130_fd_sc_hd__and2_1
XFILLER_0_0_15 VPWR VGND VPWR VGND sky130_ef_sc_hd__decap_12
XFILLER_0_43_169 VPWR VGND VPWR VGND sky130_ef_sc_hd__decap_12
X_0825_ u_apt.idx\[2\] VGND VGND VPWR VPWR _0312_ sky130_fd_sc_hd__inv_2
X_0756_ _0262_ VGND VGND VPWR VPWR _0031_ sky130_fd_sc_hd__clkbuf_1
XFILLER_0_3_277 VGND VGND VPWR VPWR sky130_fd_sc_hd__decap_3
X_0687_ _0157_ _0183_ VGND VGND VPWR VPWR _0209_ sky130_fd_sc_hd__or2_1
XFILLER_0_36_3 VPWR VGND VPWR VGND sky130_ef_sc_hd__decap_12
X_1308_ clknet_4_10_0_clk _0090_ VGND VGND VPWR VPWR u_uart.shreg\[4\] sky130_fd_sc_hd__dfxtp_1
X_1239_ clknet_4_1_0_clk _0023_ VGND VGND VPWR VPWR warm\[1\] sky130_fd_sc_hd__dfxtp_1
XFILLER_0_19_111 VGND VGND VPWR VPWR sky130_fd_sc_hd__fill_1
XFILLER_0_19_144 VGND VGND VPWR VPWR sky130_fd_sc_hd__fill_1
XFILLER_0_31_15 VGND VGND VPWR VPWR sky130_fd_sc_hd__decap_6
X_0610_ u_ro_bank.g_ro\[5\].u_ro.n\[12\] u_ro_bank.g_ro\[4\].u_ro.n\[10\] VGND VGND
+ VPWR VPWR _0149_ sky130_fd_sc_hd__xnor2_1
XFILLER_0_0_225 VPWR VGND VPWR VGND sky130_ef_sc_hd__decap_12
X_1024_ _0439_ _0462_ _0464_ VGND VGND VPWR VPWR _0466_ sky130_fd_sc_hd__o21ai_1
X_0808_ net55 _0296_ _0299_ _0172_ VGND VGND VPWR VPWR _0046_ sky130_fd_sc_hd__o211a_1
X_0739_ u_apt.rst_n VGND VGND VPWR VPWR _0251_ sky130_fd_sc_hd__buf_2
XFILLER_0_39_239 VGND VGND VPWR VPWR sky130_fd_sc_hd__decap_4
XFILLER_0_47_261 VPWR VGND VPWR VGND sky130_ef_sc_hd__decap_12
XFILLER_0_30_194 VGND VGND VPWR VPWR sky130_fd_sc_hd__fill_2
XFILLER_0_30_161 VGND VGND VPWR VPWR sky130_fd_sc_hd__decap_8
XFILLER_0_15_191 VGND VGND VPWR VPWR sky130_fd_sc_hd__decap_3
Xhold93 div\[30\] VGND VGND VPWR VPWR net99 sky130_fd_sc_hd__dlygate4sd3_1
Xhold82 u_apt.idx\[6\] VGND VGND VPWR VPWR net88 sky130_fd_sc_hd__dlygate4sd3_1
Xhold60 warm\[15\] VGND VGND VPWR VPWR net66 sky130_fd_sc_hd__dlygate4sd3_1
Xhold71 byte_reg\[6\] VGND VGND VPWR VPWR net77 sky130_fd_sc_hd__dlygate4sd3_1
XFILLER_0_26_15 VGND VGND VPWR VPWR sky130_fd_sc_hd__fill_2
XFILLER_0_38_250 VGND VGND VPWR VPWR sky130_fd_sc_hd__fill_2
Xclkbuf_4_14_0_clk clknet_0_clk VGND VGND VPWR VPWR clknet_4_14_0_clk sky130_fd_sc_hd__clkbuf_8
XFILLER_0_6_14 VPWR VGND VPWR VGND sky130_ef_sc_hd__decap_12
XFILLER_0_13_117 VGND VGND VPWR VPWR sky130_fd_sc_hd__decap_3
XFILLER_0_13_128 VPWR VGND VPWR VGND sky130_ef_sc_hd__decap_12
XTAP_345 VGND VPWR sky130_fd_sc_hd__tapvpwrvgnd_1
XTAP_334 VGND VPWR sky130_fd_sc_hd__tapvpwrvgnd_1
XTAP_323 VGND VPWR sky130_fd_sc_hd__tapvpwrvgnd_1
XTAP_312 VGND VPWR sky130_fd_sc_hd__tapvpwrvgnd_1
XTAP_301 VGND VPWR sky130_fd_sc_hd__tapvpwrvgnd_1
XPHY_18 VGND VGND VPWR VPWR sky130_fd_sc_hd__decap_3
X_1007_ net20 _0440_ _0453_ _0372_ VGND VGND VPWR VPWR _0091_ sky130_fd_sc_hd__o211a_1
XPHY_29 VGND VGND VPWR VPWR sky130_fd_sc_hd__decap_3
XFILLER_0_44_253 VPWR VGND VPWR VGND sky130_ef_sc_hd__decap_12
XFILLER_0_8_122 VPWR VGND VPWR VGND sky130_ef_sc_hd__decap_12
XFILLER_0_29_261 VPWR VGND VPWR VGND sky130_ef_sc_hd__decap_12
XFILLER_0_12_194 VGND VGND VPWR VPWR sky130_fd_sc_hd__fill_2
XFILLER_0_35_275 VGND VGND VPWR VPWR sky130_fd_sc_hd__decap_4
XFILLER_0_35_253 VGND VGND VPWR VPWR sky130_fd_sc_hd__fill_2
Xoutput4 net4 VGND VGND VPWR VPWR health_fail sky130_fd_sc_hd__buf_2
XFILLER_0_37_69 VGND VGND VPWR VPWR sky130_fd_sc_hd__decap_6
XFILLER_0_18_209 VPWR VGND VPWR VGND sky130_ef_sc_hd__decap_12
XFILLER_0_41_289 VGND VGND VPWR VPWR sky130_fd_sc_hd__fill_2
XFILLER_0_41_278 VGND VGND VPWR VPWR sky130_fd_sc_hd__fill_2
XFILLER_0_5_169 VGND VGND VPWR VPWR sky130_fd_sc_hd__fill_1
Xu_ro_bank.g_ro\[1\].u_ro.g_stg\[3\].u_inv_u_cell u_ro_bank.g_ro\[1\].u_ro.n\[2\]
+ VGND VGND VPWR VPWR u_ro_bank.g_ro\[1\].u_ro.n\[3\] sky130_fd_sc_hd__inv_1
XTAP_131 VGND VPWR sky130_fd_sc_hd__tapvpwrvgnd_1
XTAP_120 VGND VPWR sky130_fd_sc_hd__tapvpwrvgnd_1
XTAP_142 VGND VPWR sky130_fd_sc_hd__tapvpwrvgnd_1
XTAP_153 VGND VPWR sky130_fd_sc_hd__tapvpwrvgnd_1
XTAP_164 VGND VPWR sky130_fd_sc_hd__tapvpwrvgnd_1
XTAP_175 VGND VPWR sky130_fd_sc_hd__tapvpwrvgnd_1
XTAP_186 VGND VPWR sky130_fd_sc_hd__tapvpwrvgnd_1
XTAP_197 VGND VPWR sky130_fd_sc_hd__tapvpwrvgnd_1
XFILLER_0_23_27 VPWR VGND VPWR VGND sky130_ef_sc_hd__decap_12
XFILLER_0_23_223 VGND VGND VPWR VPWR sky130_fd_sc_hd__fill_1
XFILLER_0_23_289 VGND VGND VPWR VPWR sky130_fd_sc_hd__fill_2
XFILLER_0_48_57 VPWR VGND VPWR VGND sky130_ef_sc_hd__decap_12
XFILLER_0_3_15 VGND VGND VPWR VPWR sky130_fd_sc_hd__fill_1
X_1341_ clknet_4_4_0_clk _0123_ VGND VGND VPWR VPWR div\[8\] sky130_fd_sc_hd__dfxtp_1
X_1272_ clknet_4_6_0_clk _0054_ VGND VGND VPWR VPWR u_apt.idx\[6\] sky130_fd_sc_hd__dfxtp_1
X_0987_ u_uart.busy _0436_ _0438_ VGND VGND VPWR VPWR _0439_ sky130_fd_sc_hd__a21o_2
XFILLER_0_14_234 VPWR VGND VPWR VGND sky130_ef_sc_hd__decap_12
XFILLER_0_1_161 VGND VGND VPWR VPWR sky130_fd_sc_hd__decap_6
XFILLER_0_14_289 VGND VGND VPWR VPWR sky130_fd_sc_hd__fill_2
XFILLER_0_18_27 VGND VGND VPWR VPWR sky130_fd_sc_hd__fill_1
XFILLER_0_34_26 VGND VGND VPWR VPWR sky130_fd_sc_hd__fill_2
X_0910_ _0376_ _0377_ VGND VGND VPWR VPWR _0378_ sky130_fd_sc_hd__nand2_1
X_0841_ _0323_ VGND VGND VPWR VPWR _0055_ sky130_fd_sc_hd__clkbuf_1
X_0772_ u_apt.b u_rct.last VGND VGND VPWR VPWR _0272_ sky130_fd_sc_hd__xor2_2
X_1255_ clknet_4_13_0_clk net8 net1 VGND VGND VPWR VPWR u_apt.rst_n sky130_fd_sc_hd__dfrtp_4
X_1186_ div\[23\] div\[22\] div\[24\] _0577_ VGND VGND VPWR VPWR _0585_ sky130_fd_sc_hd__and4_2
X_1324_ clknet_4_2_0_clk _0106_ VGND VGND VPWR VPWR u_uart.clk_cnt\[8\] sky130_fd_sc_hd__dfxtp_1
XFILLER_0_46_101 VGND VGND VPWR VPWR sky130_fd_sc_hd__decap_4
XFILLER_0_40_80 VGND VGND VPWR VPWR sky130_fd_sc_hd__decap_4
XFILLER_0_6_253 VPWR VGND VPWR VGND sky130_ef_sc_hd__decap_12
XFILLER_0_37_167 VGND VGND VPWR VPWR sky130_fd_sc_hd__fill_1
X_1040_ _0477_ VGND VGND VPWR VPWR _0100_ sky130_fd_sc_hd__clkbuf_1
XFILLER_0_0_27 VGND VGND VPWR VPWR sky130_fd_sc_hd__fill_1
X_0824_ net18 VGND VGND VPWR VPWR _0311_ sky130_fd_sc_hd__inv_2
X_0755_ net75 _0237_ VGND VGND VPWR VPWR _0262_ sky130_fd_sc_hd__and2_1
XFILLER_0_9_47 VGND VGND VPWR VPWR sky130_fd_sc_hd__decap_8
XFILLER_0_3_289 VGND VGND VPWR VPWR sky130_fd_sc_hd__fill_2
XFILLER_0_19_81 VGND VGND VPWR VPWR sky130_fd_sc_hd__decap_3
X_0686_ _0208_ VGND VGND VPWR VPWR _0015_ sky130_fd_sc_hd__clkbuf_1
X_1169_ _0571_ _0535_ _0572_ VGND VGND VPWR VPWR _0573_ sky130_fd_sc_hd__and3b_1
X_1307_ clknet_4_10_0_clk _0089_ VGND VGND VPWR VPWR u_uart.shreg\[3\] sky130_fd_sc_hd__dfxtp_1
X_1238_ clknet_4_1_0_clk _0022_ VGND VGND VPWR VPWR warm\[0\] sky130_fd_sc_hd__dfxtp_1
XFILLER_0_29_3 VGND VGND VPWR VPWR sky130_fd_sc_hd__decap_8
XFILLER_0_19_167 VGND VGND VPWR VPWR sky130_fd_sc_hd__fill_1
XFILLER_0_0_237 VPWR VGND VPWR VGND sky130_ef_sc_hd__decap_12
X_1023_ _0464_ _0462_ _0425_ _0426_ VGND VGND VPWR VPWR _0465_ sky130_fd_sc_hd__o211a_1
XFILLER_0_16_137 VGND VGND VPWR VPWR sky130_fd_sc_hd__decap_3
X_0738_ warm\[4\] _0247_ VGND VGND VPWR VPWR _0250_ sky130_fd_sc_hd__and2_1
X_0807_ u_apt.b _0231_ VGND VGND VPWR VPWR _0299_ sky130_fd_sc_hd__or2_1
X_0669_ _0175_ _0195_ VGND VGND VPWR VPWR _0196_ sky130_fd_sc_hd__and2_1
XFILLER_0_1_81 VPWR VGND VPWR VGND sky130_ef_sc_hd__decap_12
XFILLER_0_47_273 VGND VGND VPWR VPWR sky130_fd_sc_hd__decap_6
Xhold94 u_apt.cnt\[13\] VGND VGND VPWR VPWR net100 sky130_fd_sc_hd__dlygate4sd3_1
Xhold72 div\[12\] VGND VGND VPWR VPWR net78 sky130_fd_sc_hd__dlygate4sd3_1
Xhold61 u_apt.cnt\[11\] VGND VGND VPWR VPWR net67 sky130_fd_sc_hd__dlygate4sd3_1
Xhold50 u_uart.clk_cnt\[5\] VGND VGND VPWR VPWR net56 sky130_fd_sc_hd__dlygate4sd3_1
Xhold83 u_uart.clk_cnt\[4\] VGND VGND VPWR VPWR net89 sky130_fd_sc_hd__dlygate4sd3_1
XFILLER_0_42_15 VPWR VGND VPWR VGND sky130_ef_sc_hd__decap_12
XFILLER_0_6_26 VGND VGND VPWR VPWR sky130_fd_sc_hd__fill_2
XFILLER_0_21_151 VPWR VGND VPWR VGND sky130_ef_sc_hd__decap_12
XTAP_346 VGND VPWR sky130_fd_sc_hd__tapvpwrvgnd_1
XTAP_335 VGND VPWR sky130_fd_sc_hd__tapvpwrvgnd_1
XTAP_324 VGND VPWR sky130_fd_sc_hd__tapvpwrvgnd_1
XTAP_313 VGND VPWR sky130_fd_sc_hd__tapvpwrvgnd_1
XTAP_302 VGND VPWR sky130_fd_sc_hd__tapvpwrvgnd_1
XPHY_19 VGND VGND VPWR VPWR sky130_fd_sc_hd__decap_3
X_1006_ _0441_ _0452_ VGND VGND VPWR VPWR _0453_ sky130_fd_sc_hd__or2_1
XFILLER_0_44_265 VPWR VGND VPWR VGND sky130_ef_sc_hd__decap_12
XFILLER_0_32_70 VGND VGND VPWR VPWR sky130_fd_sc_hd__fill_1
XFILLER_0_8_134 VGND VGND VPWR VPWR sky130_fd_sc_hd__decap_6
XFILLER_0_29_273 VGND VGND VPWR VPWR sky130_fd_sc_hd__decap_6
Xu_ro_bank.g_ro\[7\].u_ro.g_stg\[4\].u_inv_u_cell u_ro_bank.g_ro\[7\].u_ro.n\[3\]
+ VGND VGND VPWR VPWR u_ro_bank.g_ro\[7\].u_ro.n\[4\] sky130_fd_sc_hd__inv_1
Xoutput5 net5 VGND VGND VPWR VPWR tx sky130_fd_sc_hd__clkbuf_4
XFILLER_0_37_15 VGND VGND VPWR VPWR sky130_fd_sc_hd__fill_2
XTAP_132 VGND VPWR sky130_fd_sc_hd__tapvpwrvgnd_1
XTAP_121 VGND VPWR sky130_fd_sc_hd__tapvpwrvgnd_1
XTAP_110 VGND VPWR sky130_fd_sc_hd__tapvpwrvgnd_1
XTAP_143 VGND VPWR sky130_fd_sc_hd__tapvpwrvgnd_1
XTAP_154 VGND VPWR sky130_fd_sc_hd__tapvpwrvgnd_1
XTAP_165 VGND VPWR sky130_fd_sc_hd__tapvpwrvgnd_1
XTAP_176 VGND VPWR sky130_fd_sc_hd__tapvpwrvgnd_1
XTAP_187 VGND VPWR sky130_fd_sc_hd__tapvpwrvgnd_1
XTAP_198 VGND VPWR sky130_fd_sc_hd__tapvpwrvgnd_1
XFILLER_0_11_3 VGND VGND VPWR VPWR sky130_fd_sc_hd__fill_2
XFILLER_0_32_213 VPWR VGND VPWR VGND sky130_ef_sc_hd__decap_12
Xclkbuf_4_13_0_clk clknet_0_clk VGND VGND VPWR VPWR clknet_4_13_0_clk sky130_fd_sc_hd__clkbuf_8
XFILLER_0_23_39 VPWR VGND VPWR VGND sky130_ef_sc_hd__decap_12
XFILLER_0_48_47 VGND VGND VPWR VPWR sky130_fd_sc_hd__fill_1
X_1340_ clknet_4_4_0_clk _0122_ VGND VGND VPWR VPWR div\[7\] sky130_fd_sc_hd__dfxtp_1
XFILLER_0_48_69 VPWR VGND VPWR VGND sky130_ef_sc_hd__decap_12
X_1271_ clknet_4_6_0_clk _0053_ VGND VGND VPWR VPWR u_apt.idx\[5\] sky130_fd_sc_hd__dfxtp_1
X_0986_ tx_pending u_uart.busy VGND VGND VPWR VPWR _0438_ sky130_fd_sc_hd__nor2_1
XFILLER_0_13_61 VGND VGND VPWR VPWR sky130_fd_sc_hd__fill_1
XFILLER_0_14_246 VGND VGND VPWR VPWR sky130_fd_sc_hd__decap_6
XFILLER_0_0_3 VPWR VGND VPWR VGND sky130_ef_sc_hd__decap_12
Xu_ro_bank.g_ro\[3\].u_ro.g_stg\[7\].u_inv_u_cell u_ro_bank.g_ro\[3\].u_ro.n\[6\]
+ VGND VGND VPWR VPWR u_ro_bank.g_ro\[3\].u_ro.n\[7\] sky130_fd_sc_hd__inv_1
X_0771_ u_rct.cnt\[6\] u_rct.cnt\[5\] _0270_ VGND VGND VPWR VPWR _0271_ sky130_fd_sc_hd__and3_2
X_0840_ _0321_ _0251_ _0322_ VGND VGND VPWR VPWR _0323_ sky130_fd_sc_hd__and3b_1
X_1323_ clknet_4_8_0_clk _0105_ VGND VGND VPWR VPWR u_uart.clk_cnt\[7\] sky130_fd_sc_hd__dfxtp_1
X_1254_ clknet_4_13_0_clk net6 net1 VGND VGND VPWR VPWR u_rst_sync.sr\[0\] sky130_fd_sc_hd__dfrtp_1
X_1185_ _0583_ _0581_ _0584_ _0521_ VGND VGND VPWR VPWR _0138_ sky130_fd_sc_hd__o211a_1
XFILLER_0_24_82 VGND VGND VPWR VPWR sky130_fd_sc_hd__fill_2
XFILLER_0_6_265 VPWR VGND VPWR VGND sky130_ef_sc_hd__decap_12
X_0969_ u_apt.b _0232_ u_vn.first VGND VGND VPWR VPWR _0423_ sky130_fd_sc_hd__or3b_1
XFILLER_0_37_113 VGND VGND VPWR VPWR sky130_fd_sc_hd__decap_4
XFILLER_0_20_29 VGND VGND VPWR VPWR sky130_fd_sc_hd__decap_6
XFILLER_0_29_49 VGND VGND VPWR VPWR sky130_fd_sc_hd__decap_6
XFILLER_0_45_15 VPWR VGND VPWR VGND sky130_ef_sc_hd__decap_12
X_0823_ _0310_ VGND VGND VPWR VPWR _0050_ sky130_fd_sc_hd__clkbuf_1
X_0754_ net13 _0260_ _0166_ VGND VGND VPWR VPWR _0030_ sky130_fd_sc_hd__o21a_1
X_0685_ _0201_ _0156_ _0207_ VGND VGND VPWR VPWR _0208_ sky130_fd_sc_hd__and3_1
X_1306_ clknet_4_10_0_clk _0088_ VGND VGND VPWR VPWR u_uart.shreg\[2\] sky130_fd_sc_hd__dfxtp_1
X_1168_ div\[19\] _0568_ VGND VGND VPWR VPWR _0572_ sky130_fd_sc_hd__or2_1
X_1237_ clknet_4_5_0_clk _0021_ VGND VGND VPWR VPWR net3 sky130_fd_sc_hd__dfxtp_1
XFILLER_0_35_92 VGND VGND VPWR VPWR sky130_fd_sc_hd__decap_8
X_1099_ div\[0\] _0521_ VGND VGND VPWR VPWR _0522_ sky130_fd_sc_hd__and2b_1
XFILLER_0_42_193 VGND VGND VPWR VPWR sky130_fd_sc_hd__decap_3
XFILLER_0_42_160 VGND VGND VPWR VPWR sky130_fd_sc_hd__decap_8
XFILLER_0_0_249 VGND VGND VPWR VPWR sky130_fd_sc_hd__decap_3
X_1022_ net102 VGND VGND VPWR VPWR _0464_ sky130_fd_sc_hd__inv_2
XFILLER_0_16_149 VGND VGND VPWR VPWR sky130_fd_sc_hd__fill_1
XFILLER_0_21_61 VPWR VGND VPWR VGND sky130_ef_sc_hd__decap_12
X_0806_ _0289_ _0298_ VGND VGND VPWR VPWR _0045_ sky130_fd_sc_hd__nor2_1
X_0737_ _0249_ VGND VGND VPWR VPWR _0025_ sky130_fd_sc_hd__clkbuf_1
X_0668_ u_vn.o _0183_ _0185_ _0194_ byte_reg\[3\] VGND VGND VPWR VPWR _0195_ sky130_fd_sc_hd__a32o_1
XFILLER_0_41_3 VPWR VGND VPWR VGND sky130_ef_sc_hd__decap_12
XFILLER_0_1_93 VPWR VGND VPWR VGND sky130_ef_sc_hd__decap_12
XFILLER_0_30_174 VPWR VGND VPWR VGND sky130_ef_sc_hd__decap_12
Xu_ro_bank.g_ro\[2\].u_ro.g_stg\[3\].u_inv_u_cell u_ro_bank.g_ro\[2\].u_ro.n\[2\]
+ VGND VGND VPWR VPWR u_ro_bank.g_ro\[2\].u_ro.n\[3\] sky130_fd_sc_hd__inv_1
Xhold40 u_uart.tx_data\[1\] VGND VGND VPWR VPWR net46 sky130_fd_sc_hd__dlygate4sd3_1
Xhold73 u_rct.cnt\[3\] VGND VGND VPWR VPWR net79 sky130_fd_sc_hd__dlygate4sd3_1
Xhold84 u_rct.cnt\[0\] VGND VGND VPWR VPWR net90 sky130_fd_sc_hd__dlygate4sd3_1
Xhold95 u_rct.cnt\[6\] VGND VGND VPWR VPWR net101 sky130_fd_sc_hd__dlygate4sd3_1
Xhold62 u_uart.clk_cnt\[6\] VGND VGND VPWR VPWR net68 sky130_fd_sc_hd__dlygate4sd3_1
Xhold51 _0103_ VGND VGND VPWR VPWR net57 sky130_fd_sc_hd__dlygate4sd3_1
XFILLER_0_42_27 VGND VGND VPWR VPWR sky130_fd_sc_hd__fill_1
XTAP_314 VGND VPWR sky130_fd_sc_hd__tapvpwrvgnd_1
XTAP_303 VGND VPWR sky130_fd_sc_hd__tapvpwrvgnd_1
XFILLER_0_21_163 VGND VGND VPWR VPWR sky130_fd_sc_hd__decap_4
XTAP_347 VGND VPWR sky130_fd_sc_hd__tapvpwrvgnd_1
XTAP_336 VGND VPWR sky130_fd_sc_hd__tapvpwrvgnd_1
XTAP_325 VGND VPWR sky130_fd_sc_hd__tapvpwrvgnd_1
X_1005_ u_uart.tx_data\[5\] u_uart.shreg\[6\] _0424_ VGND VGND VPWR VPWR _0452_ sky130_fd_sc_hd__mux2_1
XFILLER_0_44_277 VPWR VGND VPWR VGND sky130_ef_sc_hd__decap_12
XFILLER_0_44_200 VGND VGND VPWR VPWR sky130_fd_sc_hd__decap_8
XFILLER_0_41_236 VGND VGND VPWR VPWR sky130_fd_sc_hd__decap_8
XTAP_133 VGND VPWR sky130_fd_sc_hd__tapvpwrvgnd_1
XTAP_122 VGND VPWR sky130_fd_sc_hd__tapvpwrvgnd_1
XTAP_100 VGND VPWR sky130_fd_sc_hd__tapvpwrvgnd_1
XTAP_111 VGND VPWR sky130_fd_sc_hd__tapvpwrvgnd_1
XTAP_144 VGND VPWR sky130_fd_sc_hd__tapvpwrvgnd_1
XTAP_155 VGND VPWR sky130_fd_sc_hd__tapvpwrvgnd_1
XTAP_166 VGND VPWR sky130_fd_sc_hd__tapvpwrvgnd_1
.ends
